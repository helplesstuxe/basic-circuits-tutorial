* 04 page2 例3 / 图04-p2-3：三运放仪表放大器，R=10k（两只），Rg=1k，后级四只 10k 差分（倍数 1）；LM358B ±15 V（假设）
* 页面：V1=2.00 V、V2=2.01 V → Rg 电流 10 µA，A2 输出 2.11 V，A1 输出 1.90 V，差 0.21 V，Vo = 21 × 10 mV = 0.21 V
* 用瞬态：VR 0.1 ms 内 0→1 V，E1/E2 给出 V1、V2，2 ms 时读稳态
.include ../models/LMx58B_LM2904B.lib
.options method=gear reltol=1e-4
VP vcc 0 15
VN vee 0 -15
VR r 0 PWL(0 0 100u 1)
E1 n1 0 r 0 2.00
E2 n2 0 r 0 2.01
XA1 n1 a1m vcc vee a1o LMX58B_LM2904B
XA2 n2 a2m vcc vee a2o LMX58B_LM2904B
RF1 a1o a1m 10k
RG a1m a2m 1k
RF2 a2o a2m 10k
RD1 a1o m 10k
RD2 m o 10k
RD3 a2o p 10k
RD4 p 0 10k
XA3 p m vcc vee o LMX58B_LM2904B
.control
tran 10u 2m
meas tran a1 find v(a1o) at=1.9m
meas tran a2 find v(a2o) at=1.9m
meas tran vo find v(o) at=1.9m
let vg = v(a2m)-v(a1m)
meas tran vgx find vg at=1.9m
echo "RES a1 $&a1"
echo "RES a2 $&a2"
echo "RES vo $&vo"
echo "RES vrg $&vgx"
.endc
.end
