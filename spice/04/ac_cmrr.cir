* 04 差分放大的共模抑制（page2 §一、图04-p2-2；page3 图04-p3-1、图04-p3-2、练习3）。LM358B，±15 V（假设），交流分析，读 50 Hz
* 约定同页面 page3 §三：分别只给 V1、只给 V2 加 1 V 交流，得两路倍数 A1（负）、A2（复数，echo 实部/虚部）；
*   run.py 算差分倍数 = (A2 − A1)/2，共模倍数 = |A1 + A2|，CMRR = 20 lg(差分/共模)
* 信号源内阻直接并进 R1（R1 + Rs）
* m: 四只匹配（只剩运放自身的共模抑制）
* r4a: page2 §一/仿真、图04-p3-1：只有 R4 偏大 1%（101k）→ 共模倍数 0.009，约 61 dB
* r4b: 图04-p3-1：只有 R4 偏大 0.1% → 约 81 dB
* wa: 图04-p3-1：四只各偏 1%，最坏组合（R1、R4 偏大，R2、R3 偏小）→ 约 49 dB
* wb: 图04-p3-1：四只各偏 0.1% 最坏 → 约 69 dB
* ga: page3 §二 TI 手册倍数 1 的例子：1% 最坏 → 约 34 dB
* gb: page3 §二 倍数 1、0.1% 最坏 → 约 54 dB
* s100: 图04-p3-2：V1 一侧内阻 100 Ω（与 R1 串联）→ 约 61 dB
* s1k: 图04-p3-2：内阻 1 kΩ → 约 41 dB，差分倍数 9.13
* s200: page3 练习3：内阻 200 Ω → 差分倍数约 9.81，共模倍数约 0.018
.include ../models/LMx58B_LM2904B.lib
VP vcc 0 15
VN vee 0 -15
VC c 0 DC 0 AC 1
E1 n1 0 c 0 1
E2 n2 0 c 0 0
R1 n1 m 10000
R2 m o 100000
R3 n2 p 10000
R4 p 0 100000
X1 p m vcc vee o LMX58B_LM2904B
.control
alter E1 gain=1
alter E2 gain=0
ac lin 3 40 60
meas ac a1r find vr(o) at=50
meas ac a1i find vi(o) at=50
echo "RES a1r_m $&a1r"
echo "RES a1i_m $&a1i"
alter E1 gain=0
alter E2 gain=1
ac lin 3 40 60
meas ac a2r find vr(o) at=50
meas ac a2i find vi(o) at=50
echo "RES a2r_m $&a2r"
echo "RES a2i_m $&a2i"
alter R1 resistance=10000
alter R2 resistance=100000
alter R3 resistance=10000
alter R4 resistance=101000
alter E1 gain=1
alter E2 gain=0
ac lin 3 40 60
meas ac a1r find vr(o) at=50
meas ac a1i find vi(o) at=50
echo "RES a1r_r4a $&a1r"
echo "RES a1i_r4a $&a1i"
alter E1 gain=0
alter E2 gain=1
ac lin 3 40 60
meas ac a2r find vr(o) at=50
meas ac a2i find vi(o) at=50
echo "RES a2r_r4a $&a2r"
echo "RES a2i_r4a $&a2i"
alter R1 resistance=10000
alter R2 resistance=100000
alter R3 resistance=10000
alter R4 resistance=100100
alter E1 gain=1
alter E2 gain=0
ac lin 3 40 60
meas ac a1r find vr(o) at=50
meas ac a1i find vi(o) at=50
echo "RES a1r_r4b $&a1r"
echo "RES a1i_r4b $&a1i"
alter E1 gain=0
alter E2 gain=1
ac lin 3 40 60
meas ac a2r find vr(o) at=50
meas ac a2i find vi(o) at=50
echo "RES a2r_r4b $&a2r"
echo "RES a2i_r4b $&a2i"
alter R1 resistance=10100
alter R2 resistance=99000
alter R3 resistance=9900
alter R4 resistance=101000
alter E1 gain=1
alter E2 gain=0
ac lin 3 40 60
meas ac a1r find vr(o) at=50
meas ac a1i find vi(o) at=50
echo "RES a1r_wa $&a1r"
echo "RES a1i_wa $&a1i"
alter E1 gain=0
alter E2 gain=1
ac lin 3 40 60
meas ac a2r find vr(o) at=50
meas ac a2i find vi(o) at=50
echo "RES a2r_wa $&a2r"
echo "RES a2i_wa $&a2i"
alter R1 resistance=10010
alter R2 resistance=99900
alter R3 resistance=9990
alter R4 resistance=100100
alter E1 gain=1
alter E2 gain=0
ac lin 3 40 60
meas ac a1r find vr(o) at=50
meas ac a1i find vi(o) at=50
echo "RES a1r_wb $&a1r"
echo "RES a1i_wb $&a1i"
alter E1 gain=0
alter E2 gain=1
ac lin 3 40 60
meas ac a2r find vr(o) at=50
meas ac a2i find vi(o) at=50
echo "RES a2r_wb $&a2r"
echo "RES a2i_wb $&a2i"
alter R1 resistance=10100
alter R2 resistance=9900
alter R3 resistance=9900
alter R4 resistance=10100
alter E1 gain=1
alter E2 gain=0
ac lin 3 40 60
meas ac a1r find vr(o) at=50
meas ac a1i find vi(o) at=50
echo "RES a1r_ga $&a1r"
echo "RES a1i_ga $&a1i"
alter E1 gain=0
alter E2 gain=1
ac lin 3 40 60
meas ac a2r find vr(o) at=50
meas ac a2i find vi(o) at=50
echo "RES a2r_ga $&a2r"
echo "RES a2i_ga $&a2i"
alter R1 resistance=10010
alter R2 resistance=9990
alter R3 resistance=9990
alter R4 resistance=10010
alter E1 gain=1
alter E2 gain=0
ac lin 3 40 60
meas ac a1r find vr(o) at=50
meas ac a1i find vi(o) at=50
echo "RES a1r_gb $&a1r"
echo "RES a1i_gb $&a1i"
alter E1 gain=0
alter E2 gain=1
ac lin 3 40 60
meas ac a2r find vr(o) at=50
meas ac a2i find vi(o) at=50
echo "RES a2r_gb $&a2r"
echo "RES a2i_gb $&a2i"
alter R1 resistance=10100
alter R2 resistance=100000
alter R3 resistance=10000
alter R4 resistance=100000
alter E1 gain=1
alter E2 gain=0
ac lin 3 40 60
meas ac a1r find vr(o) at=50
meas ac a1i find vi(o) at=50
echo "RES a1r_s100 $&a1r"
echo "RES a1i_s100 $&a1i"
alter E1 gain=0
alter E2 gain=1
ac lin 3 40 60
meas ac a2r find vr(o) at=50
meas ac a2i find vi(o) at=50
echo "RES a2r_s100 $&a2r"
echo "RES a2i_s100 $&a2i"
alter R1 resistance=11000
alter R2 resistance=100000
alter R3 resistance=10000
alter R4 resistance=100000
alter E1 gain=1
alter E2 gain=0
ac lin 3 40 60
meas ac a1r find vr(o) at=50
meas ac a1i find vi(o) at=50
echo "RES a1r_s1k $&a1r"
echo "RES a1i_s1k $&a1i"
alter E1 gain=0
alter E2 gain=1
ac lin 3 40 60
meas ac a2r find vr(o) at=50
meas ac a2i find vi(o) at=50
echo "RES a2r_s1k $&a2r"
echo "RES a2i_s1k $&a2i"
alter R1 resistance=10200
alter R2 resistance=100000
alter R3 resistance=10000
alter R4 resistance=100000
alter E1 gain=1
alter E2 gain=0
ac lin 3 40 60
meas ac a1r find vr(o) at=50
meas ac a1i find vi(o) at=50
echo "RES a1r_s200 $&a1r"
echo "RES a1i_s200 $&a1i"
alter E1 gain=0
alter E2 gain=1
ac lin 3 40 60
meas ac a2r find vr(o) at=50
meas ac a2i find vi(o) at=50
echo "RES a2r_s200 $&a2r"
echo "RES a2i_s200 $&a2i"
.endc
.end
