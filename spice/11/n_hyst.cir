* 11 过载保护 · 原理与实现篇 图 11-p2-2：负载 1 A→2.6 A→1 A 慢变 + 机械起伏（与页面代码同一算法、同一随机种子 3），比较器有回差（R_H 100 kΩ），只数翻转、不切断电机
* 采样电压 PWL 由 run.py 按页面代码生成到 noise_pwl.inc（i_load × 0.1 Ω，1 ms 一点）；R_F 10 kΩ / C_F 10 μF 在 SPICE 里滤波；LM393 用 TI LM393A 官方宏模型；输出接 IRLZ44N 栅极
.include ../models/LM393A.lib
.include ../models/IRLZ44N_infineon.lib
.include noise_pwl.inc
V5 v5 0 5
RF s f 10k
CF f 0 10u
RA v5 p 33k
RB p 0 1k
RH p g 100k
RPU v5 g 2.2k
XU p f v5 0 g LM393A
XM vd g 0 irlz44n
VD vd 0 0.1
.ic v(f)=0.1
.control
tran 1m 12 0 1m
let vgs = v(g)
wrdata n_hyst_vg.txt vgs
meas tran vgend find v(g) at=11.9
echo "RES vgend $&vgend"
.endc
.end
