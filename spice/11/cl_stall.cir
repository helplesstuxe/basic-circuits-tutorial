* 11 过载保护 · 参数与调试篇 图 11-p3-1 第二行（有回差，打嗝）；直觉篇 图 11-p1-1；原理与实现篇 推导二（堵转 26 ms）
* 图 11-p2-1 完整电路：低边 R_S 0.1 Ω、R_F 10 kΩ / C_F 10u、LM393（TI LM393A 官方宏模型）、R_A 33k / R_B 1k / R_H 100k、上拉 2.2 kΩ、IRLZ44N（Infineon）
* 电机（页面只给 12 V、正常 1 A、堵转约 5 A）：按反电动势 + 线圈电阻 2.28 Ω + 电感 1 mH 建模（假设，使堵转电流约 5 A）；续流二极管 D1 用 Vishay 1N5822（页面未给型号，替代）
.include ../models/LM393A.lib
.include ../models/IRLZ44N_infineon.lib
.include ../models/1N5822_vishay.lib
V12 vm 0 12
V5 v5 0 5
XD1 d vm d1n5822
RM vm m1 2.28
LM m1 m2 1m
BEMF m2 m3 V = time < 0.1 ? 9.6 : 0
VIM m3 d 0
XM d g s irlz44n
RS s 0 0.1
RF s f 10k
CF f 0 10u
RA v5 p 33k
RB p 0 1k
RH p g 100k
RPU v5 g 2.2k
XU p f v5 0 g LM393A
.options method=gear
.control
tran 10u 0.6 0 10u
meas tran t1 when v(g)=2.5 fall=1
meas tran r1 when v(g)=2.5 rise=1
meas tran t2 when v(g)=2.5 fall=2
meas tran t3 when v(g)=2.5 fall=3
meas tran t4 when v(g)=2.5 fall=4
let ttrip = t1 - 0.1
let toff = r1 - t1
let tper = t3 - t2
let ton = t3 - t2 - (r1 - t1)
echo "RES ttrip $&ttrip"
echo "RES toff $&toff"
echo "RES tper $&tper"
echo "RES ton $&ton"
meas tran ipk max i(VIM) from=0.1 to=0.12
echo "RES ipk $&ipk"
meas tran irun avg i(VIM) from=0.05 to=0.1
echo "RES irun $&irun"
meas tran iavg avg i(VIM) from=$&t2 to=$&t4
echo "RES iavg $&iavg"
meas tran vhpk max v(f) from=$&t2 to=$&t4
meas tran vlmn min v(f) from=$&t2 to=$&t4
echo "RES vfmax $&vhpk"
echo "RES vfmin $&vlmn"
.endc
.end
