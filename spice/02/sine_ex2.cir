* 02 page3 练习2(b)：0.1 V 峰值，10k/100k 反相，±15 V
.include ../models/LMx58B_LM2904B.lib
.options method=gear reltol=1e-4 rshunt=1e10
VP vcc 0 15
VN vee 0 -15
VA a 0 SIN(0 0.1 1k)
R1 a m 10k
RF m o 100k
X1 0 m vcc vee o LMX58B_LM2904B
.control
tran 2u 4m
meas tran omax max v(o) from=2m to=4m
meas tran omin min v(o) from=2m to=4m
echo "RES omax $&omax"
echo "RES omin $&omin"
.endc
.end
