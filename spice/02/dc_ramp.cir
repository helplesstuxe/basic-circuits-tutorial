* 02 同相放大 直流值（LM358B，±15 V）——这三种接法直接 op 不收敛，改用瞬态：输入 0.1 ms 内从 0 升到目标值，1.9 ms 时读稳态
* D page1 §四 第2步 Rf=0（导线，用 1 Ω 代替），R1=10k，0.5 V → 1 倍（0.5 V）
* H page2 例1 信号源内阻 20k，R1=10k、Rf=91k，0.5 V → 约 5 V（10.1 倍）
* M page3 练习1 R1=2k、Rf=18k，0.25 V → 2.5 V
.include ../models/LMx58B_LM2904B.lib
.options method=gear reltol=1e-4
VP vcc 0 15
VN vee 0 -15
VS in 0 PWL(0 0 100u 0.5)
VS2 in2 0 PWL(0 0 100u 0.25)
XD in md vcc vee od LMX58B_LM2904B
R1d md 0 10k
RFd od md 1
RSh in ph 20k
XH ph mh vcc vee oh LMX58B_LM2904B
R1h mh 0 10k
RFh oh mh 91k
XM in2 mm vcc vee om LMX58B_LM2904B
R1m mm 0 2k
RFm om mm 18k
.control
tran 1u 2m
meas tran vod find v(od) at=1.9m
meas tran voh find v(oh) at=1.9m
meas tran vom find v(om) at=1.9m
echo "RES vod $&vod"
echo "RES voh $&voh"
echo "RES vom $&vom"
.endc
.end
