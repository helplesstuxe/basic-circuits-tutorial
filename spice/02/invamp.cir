* 02 反相放大（page2 图02-p2-1：R1=10k，Rf=100k，Vi=0.5 V，±15 V）
* 同时用 E 源"理想运放、开环增益 A"核对页面按有限 A 计算的数（A=1e5、100、1000；例2 A=1e4、R1 10k、Rf 200k、Vi 0.1）
* page2 例3：5 V 单电源（VEE 接地），Vi=+0.5 V，无负载
.include ../models/LMx58B_LM2904B.lib
VP vcc 0 15
VN vee 0 -15
VI vi 0 0.5
R1 vi m 10k
RF m o 100k
XU 0 m vcc vee o LMX58B_LM2904B
* E 源版本：o = A*(0 - m)
R1a vi ma 10k
RFa ma oa 100k
Ea oa 0 0 ma 1e5
R1b vi mb 10k
RFb mb ob 100k
Eb ob 0 0 mb 100
R1c vi mc 10k
RFc mc oc 100k
Ec oc 0 0 mc 1000
VI2 vi2 0 0.1
R1d vi2 md 10k
RFd md od 200k
Ed od 0 0 md 1e4
* 例3 单电源
V5 v5 0 5
R1s vi ms 10k
RFs ms os 100k
XUs 0 ms v5 0 os LMX58B_LM2904B
.control
op
let vo=v(o)
let vm=v(m)
let voa=v(oa)
let vma=v(ma)
let vob=v(ob)
let vmb=v(mb)
let voc=v(oc)
let vmc=v(mc)
let vod=v(od)
let vmd=v(md)
let vos=v(os)
let vms=v(ms)
echo "RES vo $&vo"
echo "RES vm $&vm"
echo "RES voa $&voa"
echo "RES vma $&vma"
echo "RES vob $&vob"
echo "RES vmb $&vmb"
echo "RES voc $&voc"
echo "RES vmc $&vmc"
echo "RES vod $&vod"
echo "RES vmd $&vmd"
echo "RES vos $&vos"
echo "RES vms $&vms"
.endc
.end
