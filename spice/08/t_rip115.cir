* 08 page2 图08-p2-1：分立线性稳压。R_Z 1 kΩ + 1N4733A 基准，LM358（TI LMx58 模型，由输入供电），TIP31（用 TIP31C 模型）调整管，R_f 3.9 kΩ / R_1 5.1 kΩ
* page3 §3 图08-p3-2：输入平均 11.5 V、纹波 2 V（谷底 10.5 V），0.5 A。页面：输出最低 8.24 V，纹波 245 mV
* 锯齿（假设）：1 ms 从谷底升到峰、9 ms 线性降回，100 Hz；VR 为谷底电压
* C_o 10 µF 在这些文件里不接：理想 10 µF 直接并在输出时该模型组合会自激（见 t_stab_C10.cir）；100 Hz 下 10 µF 的容抗 159 Ω，远大于跟随器毫欧级输出阻抗，对直流和 100 Hz 纹波结果几乎没有影响
.param VDC=10.5
.param RZV=1k
.param RFV=3.9k
.param RLV=17.66
.include ../models/LMx58_LM2904.lib
.include ../models/TIP31C_onsemi.lib
.include ../models/1N47xxA_diodes_zener.lib
.options method=trap
* 输入 i = 直流 VR + 锯齿 VS。R_Z 上端 rz = v(i) + VRMP，VRMP 在 5 ms 内从 -VDC 升到 0，之后 rz 与 i 完全相同；
* 这样基准慢慢建立、运放供电一开始就在，避开该运放模型的初始点不收敛（只影响启动，不影响 5 ms 之后的结果）
VR r 0 10.5
VS i r PWL(0 0 10m 0 11m 2 20m 0 21m 2 30m 0 31m 2 40m 0 41m 2 50m 0 51m 2 60m 0 61m 2 70m 0 71m 2 80m 0 81m 2 90m 0 91m 2 100m 0)
VRMP rz i PWL(0 {-VDC} 5m 0)
RZ rz ref {RZV}
XZ 0 ref DI_1N4733A
X1 ref fb i 0 ob LMX58_LM2904
Q1 i ob o Qtip31c
RF o fb {RFV}
R1 fb 0 5.1k
RL o 0 {RLV}
.control
tran 2u 100m 0 2u
meas tran opp pp v(o) from=50m to=100m
meas tran omn min v(o) from=50m to=100m
meas tran ipp pp v(i) from=50m to=100m
meas tran imn min v(i) from=50m to=100m
meas tran rav avg v(ref) from=50m to=100m
meas tran oav avg v(o) from=50m to=100m
meas tran izav avg i(VRMP) from=50m to=100m
echo "RES opp $&opp"
echo "RES omn $&omn"
echo "RES ipp $&ipp"
echo "RES imn $&imn"
echo "RES rav $&rav"
echo "RES oav $&oav"
echo "RES izav $&izav"
.endc
.end
