* 08 page2 图08-p2-1 C_o 10 µF 串 1 Ω ESR（普通电解电容量级，假设），输入 14 V，负载 0.05 A（170.2 Ω）。检查 page3 §4 说的"会不会振荡"
* 基准用理想 4.82 V 源（只看环路稳定性）；trap 积分；0.5 A 时该组合在启动阶段不收敛，只给出 0.05 A 结果
.include ../models/LMx58_LM2904.lib
.include ../models/TIP31C_onsemi.lib
.options method=trap
VR i 0 14
VREF ref 0 PWL(0 0 2m 4.82)
X1 ref fb i 0 ob LMX58_LM2904
Q1 i ob o Qtip31c
RF o fb 3.9k
R1 fb 0 5.1k
CO o oc 10u
RESR oc 0 1
RL o 0 170.2
.control
tran 1u 30m 0 1u
meas tran opp pp v(o) from=20m to=30m
meas tran oav avg v(o) from=20m to=30m
echo "RES opp $&opp"
echo "RES oav $&oav"
.endc
.end
