* 08 page2 §8 例3 / page3 练习4：7805 从 12 V 得 5 V、负载 1 A（页面功耗 7 W）；从 9 V 得 5 V、负载 0.5 A（页面功耗 2 W）
* 【替代模型】没有找到 7805/uA7805 的官方 SPICE 模型（TI E2E 上 TI 工程师答复 LM340 系列没有模型），这里用 TI 官方 LM317 瞬态模型
*  接成 5 V 输出（R1 240 Ω，R2 720 Ω：1.25 × (1 + 720/240) = 5.0 V）代替 7805，只用来核对 V_o 与功耗 (V_i − V_o)·I。
*  注意：该 LM317 模型是行为级模型，压差固定为 0.5 V（.PARAM drop=.5）、纹波抑制固定约 62 dB（psrr=7.9432e-4），
*  不能用来核对 7805 手册的 2 V 压差和 78 dB 纹波抑制，那两项只引用手册，不做仿真判断。
.include ../models/LM317_TRANS.lib
VI in 0 PWL(0 0 1m 12)
XU in adj out out LM317_TRANS
R1 out adj 240
R2 adj 0 720
CI in 0 0.33u
CO out 0 0.1u
RL out 0 5
.control
tran 10u 10m 0 10u
meas tran vo find v(out) at=9.5m
meas tran ii find i(VI) at=9.5m
echo "RES vo12 $&vo"
echo "RES ii12 $&ii"
alter VI pwl = [ 0 0 1m 9 ]
alter RL resistance = 10
tran 10u 10m 0 10u
meas tran vo9 find v(out) at=9.5m
meas tran ii9 find i(VI) at=9.5m
echo "RES vo9 $&vo9"
echo "RES ii9 $&ii9"
.endc
.end
