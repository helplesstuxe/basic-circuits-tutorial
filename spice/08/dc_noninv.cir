* 08 同相放大 直流工作点（LM358B，±15 V，输出无外接负载）——一个运放，用 alter 逐个换元件值重算 op
* （多个 TI 运放放在同一网表里工作点不收敛，所以改成单运放 + alter；
* D、H、M 三种接法 op 本身不收敛，放在 dc_ramp.cir 里用“输入从 0 慢慢升上去”的瞬态求稳态）
* A page1 §一 10k/20k：0.5 V→1.5 V；page2 §一 第二步 反相端 = 输出的 1/3（= 输入）
* B page1 §一 −0.2 V→−0.6 V
* C page1 §四 第2步 Rf=40k → 5 倍（0.5 V→2.5 V）
* E page1 §四 第3步 信号源串 100 kΩ，输出几乎不变（仍 1.5 V）
* K page2 例2 10k/30k，0.3 V → 1.2 V
* Q page3 练习2 同相：内阻 50k、空载 1 V，10k/20k → 3 V
* R （补充）内阻 1 MΩ，10k/20k，0.5 V（输入偏置电流流过内阻的影响）
.include ../models/LMx58B_LM2904B.lib
VP vcc 0 15
VN vee 0 -15
VS in 0 0.5
RS in p 1m
X1 p m vcc vee o LMX58B_LM2904B
R1 m 0 10k
RF o m 20k
.control
op
echo "RES voa $&v(o)"
echo "RES vma $&v(m)"
alter VS dc=-0.2
op
echo "RES vob $&v(o)"
alter VS dc=0.5
alter RF resistance=40k
op
echo "RES voc $&v(o)"
alter RF resistance=20k
alter RS resistance=100k
op
echo "RES voe $&v(o)"
alter RS resistance=1Meg
op
echo "RES vor $&v(o)"
alter RS resistance=1m
alter RF resistance=30k
alter VS dc=0.3
op
echo "RES vok $&v(o)"
alter RF resistance=20k
alter RS resistance=50k
alter VS dc=1
op
echo "RES voq $&v(o)"
.endc
.end
