* 08 page2 图08-p2-1 原样（含 C_o 10 µF，理想电容 ESR = 0）：输入 14 V，负载 0.5 A（17.02 Ω）。检查 page3 §4 说的"会不会振荡"
* 基准按页面 R_Z 1 kΩ + 1N4733A；gear 积分 + uic，输入 2 ms 从 0 升到 14 V（trap 积分同样得到持续振荡，幅度略不同）
.include ../models/LMx58_LM2904.lib
.include ../models/TIP31C_onsemi.lib
.options method=gear
VR i 0 PWL(0 0 2m 14)
.include ../models/1N47xxA_diodes_zener.lib
RZ i ref 1k
XZ 0 ref DI_1N4733A
X1 ref fb i 0 ob LMX58_LM2904
Q1 i ob o Qtip31c
RF o fb 3.9k
R1 fb 0 5.1k
CO o 0 10u
RL o 0 17.02
.control
tran 1u 30m 0 1u uic
meas tran opp pp v(o) from=20m to=30m
meas tran oav avg v(o) from=20m to=30m
echo "RES opp $&opp"
echo "RES oav $&oav"
let x = v(o) - oav
meas tran t1 when x=0 rise=200
meas tran t2 when x=0 rise=210
let ff = 10/(t2-t1)
echo "RES fosc $&ff"
.endc
.end
