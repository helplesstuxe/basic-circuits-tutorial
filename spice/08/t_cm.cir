* 08 page3 §1：共模上限——5 V 供电时即使倍数为 1，输入也不能超过约 3.5 V（V+ − 1.5 V）
* LM358B 单 5 V 供电接成跟随器（输出直接接反相端），输入 0→5 V 线性斜坡（20 ms），输出无外接负载
* 读：输出最高值、输出比输入低 50 mV 时的输入电压（跟随失效点）
.include ../models/LMx58B_LM2904B.lib
.options method=gear reltol=1e-4 rshunt=1e10
VP vcc 0 5
VS in 0 PWL(0 0 20m 5)
X1 in o vcc 0 o LMX58B_LM2904B
BE e 0 V=v(in)-v(o)-0.05
.control
tran 10u 20m
meas tran omax max v(o)
meas tran vfail find v(in) when v(e)=0 cross=last
echo "RES omax $&omax"
echo "RES vfail $&vfail"
.endc
.end
