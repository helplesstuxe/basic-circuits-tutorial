* 27 双控开关：低压版（9 V 电池 + 1 kΩ + 红色 LED 代替 220 V 灯），page2 §六 动手实验的电路
* 核对：page1 真值表；page2 §三 代码输出 [A][B][C]、§六 第 2 步 LED 电流 ≈7 mA、第 6 步灯灭时测点 ≈9 V / ≈0 V；page3 变体1 三地控制 [D] 与练习
* 不仿真 220 V 照明回路（市电）。
* LED：spice/models/LED_red_ltspice.lib 的 APT1608SURCK（LTspice 库条目，非厂家官网文件）。
* 万用表：10 MΩ 输入电阻，接在「电阻与 LED 相接点」对电池负极。
* 单刀双掷：位置 0 时 COM-1 闭合，位置 1 时 COM-2 闭合（同 code/27_sim.py 的 spdt()）。
.include ../models/LED_red_ltspice.lib
*@def S1=0
*@def S2=0
*@def S3=0
.model SWN SW(VT=0.5 VH=0.01 RON=0.05 ROFF=1e12)
VC1 c1 0 @S1@
VC2 c2 0 @S2@
VC3 c3 0 @S3@
Bn1 nc1 0 V=1-v(c1)
Bn2 nc2 0 V=1-v(c2)
Bn3 nc3 0 V=1-v(c3)
* ---- 1 正确接法：L→S1.COM；跨线 S1.1-S2.2、S1.2-S2.1；S2.COM→1k→LED→N
VB1 L1 0 9
S11a L1 A11 nc1 0 SWN
S11b L1 A12 c1 0 SWN
S12a A1c A12 nc2 0 SWN
S12b A1c A11 c2 0 SWN
R1 A1c J1 1k
D1 J1 0 APT1608SURCK
RM1 J1 0 10Meg
* ---- 2 跨线一端对调：S1.1-S2.1、S1.2-S2.2
VB2 L2 0 9
S21a L2 A21 nc1 0 SWN
S21b L2 A22 c1 0 SWN
S22a A2c A21 nc2 0 SWN
S22b A2c A22 c2 0 SWN
R2 A2c J2 1k
D2 J2 0 APT1608SURCK
RM2 J2 0 10Meg
* ---- 3 公共端接错：去灯的线接在 S2.1；跨线 S1.1-S2.2、S1.2-S2.COM
VB3 L3 0 9
S31a L3 P31 nc1 0 SWN
S31b L3 P32 c1 0 SWN
S32a P32 Q31 nc2 0 SWN
S32b P32 P31 c2 0 SWN
R3 Q31 J3 1k
D3 J3 0 APT1608SURCK
RM3 J3 0 10Meg
* ---- 4 开关接在零线（page2 §六 第 6 步）：9 V→1k→LED→S1.COM；S2.COM→负极
VB4 L4 0 9
R4 L4 J4 1k
D4 J4 K4 APT1608SURCK
RM4 J4 0 10Meg
S41a K4 A41 nc1 0 SWN
S41b K4 A42 c1 0 SWN
S42a 0 A42 nc2 0 SWN
S42b 0 A41 c2 0 SWN
* ---- 5 三地控制（page3 变体1）：S1.1→M.a1、S1.2→M.b1；M.a2→S3.2、M.b2→S3.1；S2 中途开关 0 直通 1 交叉
VB5 L5 0 9
S51a L5 Ma1 nc1 0 SWN
S51b L5 Mb1 c1 0 SWN
SM1 Ma1 Ma2 nc2 0 SWN
SM2 Mb1 Mb2 nc2 0 SWN
SM3 Ma1 Mb2 c2 0 SWN
SM4 Mb1 Ma2 c2 0 SWN
S53a A5c Mb2 nc3 0 SWN
S53b A5c Ma2 c3 0 SWN
R5 A5c J5 1k
D5 J5 0 APT1608SURCK
RM5 J5 0 10Meg
.control
op
let i1=-i(VB1)
echo "RESULT I1 $&i1"
let i2=-i(VB2)
echo "RESULT I2 $&i2"
let i3=-i(VB3)
echo "RESULT I3 $&i3"
let i4=-i(VB4)
echo "RESULT I4 $&i4"
let i5=-i(VB5)
echo "RESULT I5 $&i5"
let vj1=v(J1)
let vj4=v(J4)
echo "RESULT VJ1 $&vj1"
echo "RESULT VJ4 $&vj4"
let vf=v(J1)
echo "RESULT VF1 $&vf"
.endc
.end
