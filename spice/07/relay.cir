* 07 三极管开关与继电器驱动：线圈侧（低压 5 V / 12 V）。触点侧 220 V 不仿真（市电）。
* 核对：page1 图07-p1-2（开到底 96% / 半开 60%）；page2 §二 A 部分、例1～例3、§三 B 部分 图07-p2-2、图07-p2-3、§六 动手步骤 2～3；
*       page3 图07-p3-1（扫 R_B）、练习 2～4。
* 电路照页面：VCC → 继电器线圈（RCOIL 串 LCOIL）→ Q1 集电极；Q1 发射极接地；单片机引脚 VPIN 经 RB 接基极。
* Q1 = 2N3904（onsemi 官方模型）。D1 = 1N4148（Nexperia 官方模型），负极接 VCC；DMODE=1 仅二极管，DMODE=2 二极管串 24 V 稳压管
* （Diodes 1N4749A，负极对负极），DMODE=0 无二极管（集电极对地 100 pF 杂散电容，页面示意值）。
* 线圈电感 0.1 H 为页面示意值（SRD 手册未给）。引脚在 T0 时刻从 VPIN 跳到 0（关断）。
.include ../models/2N3904_onsemi.lib
.include ../models/1N4148_nexperia.lib
.include ../models/1N4749A_diodes_zener.lib
*@def VCC=5
*@def RCOIL=70
*@def LCOIL=0.1
*@def RB=680
*@def VPIN=5
*@def DMODE=1
*@def T0=10m
*@def TSTOP=16m
*@def TMAX=1u
VCC vcc 0 @VCC@
LC vcc m @LCOIL@
RC m c @RCOIL@
CS c 0 100p
VIN pin 0 PWL(0 @VPIN@ @T0@ @VPIN@ {@T0@+10n} 0)
RB pin b @RB@
Q1 c b 0 Q2n3904
.if (@DMODE@ == 1)
XD1 c vcc 1N4148
.elseif (@DMODE@ == 2)
XD1 c k 1N4148
XZ1 vcc k DI_1N4749A
.endif
.control
op
let ib=(v(pin)-v(b))/@RB@
let ic=(v(vcc)-v(c))/@RCOIL@
let vce=v(c)
let vcoil=v(vcc)-v(c)
let pq=v(c)*ic+v(b)*ib
echo "RESULT IB $&ib"
echo "RESULT IC $&ic"
echo "RESULT VCE $&vce"
echo "RESULT VCOIL $&vcoil"
echo "RESULT PQ $&pq"
tran 10n @TSTOP@ 0 @TMAX@ uic
let il=i(LC)
wrdata tr.dat il v(c)
meas tran VPK max v(c) from=@T0@ to=@TSTOP@
echo "RESULT VPK $&VPK"
.endc
.end
