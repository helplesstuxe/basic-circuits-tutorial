* 07 page2 §3 推导/仿真、图07-p2-3 负载扫描；page2 §6 例1–例3；page3 练习1；page3 图07-p3-1 管耗曲线
* 基极由理想电压源推动（相当于"反馈只取运放自己输出"且运放不限流），两种管子并列：Q1 = 2N3904，Q2 = TIP31C
* 页面数字按 β = 50、I_S = 1e-13 的示意模型算出；这里用厂商模型，β 和 V_BE 取模型本身的值
.include ../models/2N3904_onsemi.lib
.include ../models/TIP31C_onsemi.lib
VB b 0 5
VC1 c1 0 12
VC2 c2 0 12
Q1 c1 b e1 Q2n3904
Q2 c2 b e2 Qtip31c
RL1 e1 0 50
RL2 e2 0 50
.control
op
echo "RES r50_e1 $&v(e1)"
echo "RES r50_e2 $&v(e2)"
echo "RES r50_ib1 $&@Q1[ib]"
echo "RES r50_ib2 $&@Q2[ib]"
echo "RES r50_ic1 $&@Q1[ic]"
echo "RES r50_ic2 $&@Q2[ic]"
alter RL1 resistance=1000
alter RL2 resistance=1000
op
echo "RES r1000_e1 $&v(e1)"
echo "RES r1000_e2 $&v(e2)"
echo "RES r1000_ib1 $&@Q1[ib]"
echo "RES r1000_ib2 $&@Q2[ib]"
echo "RES r1000_ic1 $&@Q1[ic]"
echo "RES r1000_ic2 $&@Q2[ic]"
alter RL1 resistance=100
alter RL2 resistance=100
op
echo "RES r100_e1 $&v(e1)"
echo "RES r100_e2 $&v(e2)"
echo "RES r100_ib1 $&@Q1[ib]"
echo "RES r100_ib2 $&@Q2[ib]"
echo "RES r100_ic1 $&@Q1[ic]"
echo "RES r100_ic2 $&@Q2[ic]"
alter RL1 resistance=20
alter RL2 resistance=20
op
echo "RES r20_e1 $&v(e1)"
echo "RES r20_e2 $&v(e2)"
echo "RES r20_ib1 $&@Q1[ib]"
echo "RES r20_ib2 $&@Q2[ib]"
echo "RES r20_ic1 $&@Q1[ic]"
echo "RES r20_ic2 $&@Q2[ic]"
* 例1：Vi 6 V，100 Ω，12 V
alter VB dc=6
alter RL1 resistance=100
alter RL2 resistance=100
op
echo "RES x1_e1 $&v(e1)"
echo "RES x1_e2 $&v(e2)"
echo "RES x1_ib1 $&@Q1[ib]"
echo "RES x1_ib2 $&@Q2[ib]"
echo "RES x1_ic1 $&@Q1[ic]"
echo "RES x1_ic2 $&@Q2[ic]"
* 例2：Vi 3.3 V，47 Ω
alter VB dc=3.3
alter RL1 resistance=47
alter RL2 resistance=47
op
echo "RES x2_e1 $&v(e1)"
echo "RES x2_e2 $&v(e2)"
echo "RES x2_ib1 $&@Q1[ib]"
echo "RES x2_ib2 $&@Q2[ib]"
echo "RES x2_ic1 $&@Q1[ic]"
echo "RES x2_ic2 $&@Q2[ic]"
* 例3：Vi 5.7 V，50 Ω，12 V 与 7 V
alter VB dc=5.7
alter RL1 resistance=50
alter RL2 resistance=50
op
echo "RES x3_e1 $&v(e1)"
echo "RES x3_e2 $&v(e2)"
echo "RES x3_ic1 $&@Q1[ic]"
echo "RES x3_ic2 $&@Q2[ic]"
alter VC1 dc=7
alter VC2 dc=7
op
echo "RES x3b_e1 $&v(e1)"
echo "RES x3b_e2 $&v(e2)"
echo "RES x3b_ic1 $&@Q1[ic]"
echo "RES x3b_ic2 $&@Q2[ic]"
* 练习1：Vi 9 V，20 Ω，15 V（TIP31）
alter VB dc=9
alter VC1 dc=15
alter VC2 dc=15
alter RL1 resistance=20
alter RL2 resistance=20
op
echo "RES p1_e2 $&v(e2)"
echo "RES p1_ib2 $&@Q2[ib]"
echo "RES p1_ic2 $&@Q2[ic]"
* 图07-p3-1：12 V、50 Ω，扫基极电压求管耗最大值（TIP31C）
alter VC1 dc=12
alter VC2 dc=12
alter RL1 resistance=50
alter RL2 resistance=50
dc VB 0 12 0.01
let pc2 = (12 - v(e2)) * (-i(VC2))
let pc1 = (12 - v(e1)) * (-i(VC1))
meas dc pmx2 max pc2
meas dc pmx1 max pc1
meas dc vpm2 find v(e2) when pc2=pmx2
echo "RES pmx2 $&pmx2"
echo "RES pmx1 $&pmx1"
.endc
.end
