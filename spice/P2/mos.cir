* P2 MOS 管（2N7000，onsemi 官方模型）
* 对应：page2 §4 / page3 参数表（VGS(th) 0.8/2.1/3.0 V，在 ID=1 mA、VDS=VGS 下；RDS(on) 4.5 V 时最大 5.3 Ω、10 V 时最大 5 Ω）
*       page2 图P2-p2-4、page3 图P2-p3-2 是"示意模型、不对应 2N7000"，只作对照，不判对错
*       page2 例3 / page3 练习4（3.3 V 单片机直接驱动 2N7000，5 V、100 Ω 负载）
.include ../models/2N7000_onsemi.lib
* 门限：漏栅短接，扫 VGS
VG g 0 0
X1 g g 0 2n7000
* 3.3 V 直驱 5 V/100 Ω
VG3 g3 0 3.3
VDD vdd 0 5
RL vdd d3 100
X3 d3 g3 0 2n7000
* RDS(on)：VGS=4.5 V，ID=75 mA；VGS=10 V，ID=500 mA（手册测试条件）；以及 0.2 A 下 3.3/5/10 V
VG45 g45 0 4.5
ID75 0 d45 75m
X45 d45 g45 0 2n7000
VG10 g10 0 10
ID500 0 d10 500m
X10 d10 g10 0 2n7000
VGa ga 0 3.3
IDa 0 da 200m
Xa da ga 0 2n7000
VGb gb 0 5
IDb 0 db 200m
Xb db gb 0 2n7000
VGc gc 0 10
IDc 0 dc 200m
Xc dc gc 0 2n7000
.control
op
let id3=(5-v(d3))/100
let vds3=v(d3)
let r45=v(d45)/75m
let r10=v(d10)/500m
let ra=v(da)/0.2
let rb=v(db)/0.2
let rc=v(dc)/0.2
echo "RES id3 $&id3"
echo "RES vds3 $&vds3"
echo "RES r45 $&r45"
echo "RES r10 $&r10"
echo "RES ra $&ra"
echo "RES rb $&rb"
echo "RES rc $&rc"
dc VG 0 4 0.001
let idd = -i(VG)
meas dc vth when idd=1m rise=1
echo "RES vth $&vth"
.endc
.end
