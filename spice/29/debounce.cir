* 节点 29 page2 推导三 / 仿真一 / 图 29-p2-1、29-p2-2 / 例2 / page3 练习3：RC 去抖 + 74HC14 施密特反相器
* 电路：VCC—R1—A—R2—B，C 接 B 与地，按键接 A 与地；B 接 SN74HC14 输入（TI 官方行为模型）。
* 另接一路「只有 10 kΩ 上拉」的引脚 raw，与同一只按键同步（两组触点同时动作，用来数原始翻转次数）。
* 按键控制电压 ctl：>0.5 V 表示接通；默认是干净的一次按下（5 ms 按下、TREL 松开），
* run.py 会传入按页面 bounce_state(seed=3) 生成的抖动 PWL。VG：74HC14 的电源（默认 5 V，与页面电路相同）。
.include ../models/SN74HC14_TI.lib
.param R1=10k R2=10k C=1u VG=5
*@def CTL=PWL(0,0,5m,0,5.001m,1,35m,1,35.001m,0)
*@def TEND=60m
*@def TREL=35m
*@def VH=2.5
VCC vcc 0 5
VGG vg 0 {VG}
R1 vcc a {R1}
R2 a b {R2}
C1 b 0 {C} IC=5
SK a 0 ctl 0 SWK
RRAW vcc raw 10k
SRAW raw 0 ctl 0 SWK
VCTL ctl 0 @CTL@
.model SWK SW(VT=0.5 VH=0.1 RON=0.1 ROFF=1e10)
XU y b vg 0 SN74HC14
CY y 0 15p
.control
tran 2u @TEND@ 0 2u uic
meas tran tp WHEN v(y)=@VH@ RISE=1
meas tran tr WHEN v(y)=@VH@ FALL=1 FROM=@TREL@
meas tran vbmin MIN v(b) FROM=5m TO=@TREL@
echo "RESULT tp $&tp"
echo "RESULT tr $&tr"
echo "RESULT vbmin $&vbmin"
wrdata db.txt v(y) v(raw) v(b)
.endc
.end
