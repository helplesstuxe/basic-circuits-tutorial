* 14 电压比较器：page3 §1 参数表「响应时间约 1.3 µs」与「上升时间约 R3×CL，2.2 kΩ 配 15 pF 约 33 ns；1 MΩ 约 15 µs」
* LM393A，5 V，基本比较器（同相端接输入、反相端接 2.5 V 基准），R3 上拉，CL=15p。
* 输入按 LM393 手册响应时间的测试条件：100 mV 阶跃、5 mV 过驱（VLO=2.405 -> VHI=2.505 V）；10 µs 跳高，110 µs 跳回。
.include ../models/LM393A.lib
.param VLO=2.405 VHI=2.505 CL=15p R3=2.2k
VCC vcc 0 5
RA vcc ref 10k
RB ref 0 10k
VIN p 0 PWL(0 {VLO} 10u {VLO} 10.001u {VHI} 110u {VHI} 110.001u {VLO})
RR3 vcc out {R3}
CCL out 0 {CL}
XU p ref vcc 0 out LM393A
.control
tran 2n 200u 0 2n
meas tran tr_on WHEN v(out)=2.5 RISE=1
meas tran tf_on WHEN v(out)=2.5 FALL=1
meas tran t10 WHEN v(out)=0.5 RISE=1
meas tran t90 WHEN v(out)=4.5 RISE=1
echo "RESULT tplh $&tr_on"
echo "RESULT tphl $&tf_on"
echo "RESULT t10 $&t10"
echo "RESULT t90 $&t90"
.endc
.end
