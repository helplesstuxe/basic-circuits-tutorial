* 14 积分电路 · 原理与实现篇 结论三与图 14-p2-3（±1 V 500 Hz 方波 + 20 mV 直流偏置，理想积分器 vs 并 1 MΩ）；直觉篇 §示波器 第4、5步
* LM358B（TI 官方模型），±15 V；理想积分器 t < 50 μs 清零，实用积分器同样从 0 V 起（开关清零）以对照页面“初始 0 V”
.include ../models/LMx58B_LM2904B.lib
.options method=gear reltol=1e-4 rshunt=1e12
VP vcc 0 15
VN vee 0 -15
VR rst 0 PWL(0 1 49u 1 50u 0)
.model swr sw vt=0.5 vh=0.1 ron=1 roff=1e15
* 理想积分器：R 输入，C 反馈；电容旁的开关只在 t < 50 μs 时闭合，给电容清零（代替“初始输出 0 V”），之后断开（1e15 Ω）
.subckt integ in o vcc vee rst r=10k c=100n
R1 in m {r}
C1 m o {c}
S1 m o rst 0 swr
XA 0 m vcc vee o LMX58B_LM2904B
.ends
* 实用积分器：C 旁并 R_f，有直流工作点，不需要清零
.subckt pinteg in o vcc vee r=10k c=100n rf=1meg
R1 in m {r}
C1 m o {c}
R2 m o {rf}
XA 0 m vcc vee o LMX58B_LM2904B
.ends
VA a 0 PULSE(-1 1 50u 100n 100n 0.0009999 0.002)
VO ai a 20m
XI ai oi vcc vee rst integ
* 实用积分器也先清零：手工展开
R1p ai mp 10k
C1p mp op 100n
R2p mp op 1meg
S1p mp op rst 0 swr
XAp 0 mp vcc vee op LMX58B_LM2904B
.control
tran 4u 1 0 4u
meas tran vsat min v(oi) from=0.9 to=1
let vs1 = vsat + 0.05
meas tran thit when v(oi)=vs1 fall=1
meas tran c1 avg v(oi) from=0.1 to=0.12
meas tran c2 avg v(oi) from=0.3 to=0.32
let drift = (c2 - c1) / 0.2
meas tran pend avg v(op) from=0.9 to=1
meas tran pmx find v(op) at=0.951048
meas tran pmn find v(op) at=0.952048
let ppp = abs(pmx - pmn)
meas tran t135 when v(oi)=-13.5 fall=1
echo "RES t135 $&t135"
meas tran p02 avg v(op) from=0.199 to=0.201
meas tran p01 avg v(op) from=0.099 to=0.101
let tau = 0.1/ln((p01 - pend)/(p02 - pend))
echo "RES vsat $&vsat"
echo "RES thit $&thit"
echo "RES drift $&drift"
echo "RES pend $&pend"
echo "RES ppp $&ppp"
echo "RES p02 $&p02"
echo "RES tau $&tau"
.endc
.end
