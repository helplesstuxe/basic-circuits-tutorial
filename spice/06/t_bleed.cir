* 06 page3 练习3：2200 µF 电容并 4.7 kΩ 泄放电阻，断电时电压约 15.6 V（页面），看 10 s 后剩多少
* 页面：τ = RC ≈ 10 s，10 s 后降到约 37%（4.7k 时 τ = 10.34 s）；平时功率 0.052 W
C1 p 0 2200u IC=15.6
RB p 0 4.7k
.control
tran 10m 10.34 uic
meas tran v10 find v(p) at=10
meas tran vt find v(p) at=10.34
echo "RES v10 $&v10"
echo "RES vtau $&vt"
.endc
.end
