* 06 MOS 管开关：带线圈负载与续流二极管（page2 §5 图06-p2-3；page3 故障表「MOS 管击穿」行、练习 3 图06-p3-3）
* 电路（VID 为漏极电流表，0 V）：+12 V → 线圈（L=1 mH 页面示意值，串 4 Ω 使稳态电流 3 A —— 4 Ω 为假设）→ D；IRLZ44N S 接地；RG=100 Ω（扫描时改 RG）、RGS=10 kΩ、5 V 驱动。
* DMODE=1：D1 正接（阴极 +12 V、阳极漏极）；DMODE=0：无二极管；DMODE=2：D1 接反（阳极 +12 V、阴极漏极，练习 3）。
* D1 用 Vishay 1N5822 肖特基（页面只说「常用肖特基」，未给型号；3 A 级，选型为假设）。
* 时序：0 时刻开通，3 ms 关断（电流已到 3 A），T2（默认 3.02 ms）再开通（测带续流的硬开通损耗），T2+80 μs 关断；无二极管时 run.py 把 T2 推后到 3.3 ms，让雪崩能量积分完整。
.include ../models/IRLZ44N_infineon.lib
.include ../models/1N5822_vishay.lib
*@def DMODE=1
*@def RG=100
*@def T2=3.02e-3
*@def TE=3.0199m
*@def TSTOP=3.2m
VDD vdd 0 12
L1 vdd m 1m
RM m d 4
VID d dm 0
VDR drv 0 PWL(0 0 1n 0 6n 5 3m 5 3.000005m 0 @T2@ 0 {@T2@+5n} 5 {@T2@+80u} 5 {@T2@+80.005u} 0)
RG drv g @RG@
RGS g 0 10k
X1 dm g 0 irlz44n
.if (@DMODE@ == 1)
XD1 d vdd d1n5822
.elseif (@DMODE@ == 2)
XD1 vdd d d1n5822
.endif
.control
option method=gear
tran 5n @TSTOP@ 2.99m 5n
let id=i(VID)
let p=v(d)*id
meas tran ISS find id at=2.995m
meas tran VDPK max v(d) from=3m to=3.019m
meas tran IDPK max id from=0 to=3m
meas tran VDCL find v(d) at=3.005m
meas tran EOFF integ p from=3m to=@TE@
meas tran EON integ p from=3.02m to=3.03m
meas tran EAV integ p from=3m to=@TE@
meas tran ID2 find id at=3.0204m
meas tran VD2 find v(d) at=3.0204m
meas tran IDREV max id from=2.99m to=3m
echo "RESULT ISS $&ISS"
echo "RESULT VDPK $&VDPK"
echo "RESULT VDCL $&VDCL"
echo "RESULT EOFF $&EOFF"
echo "RESULT EON $&EON"
echo "RESULT EAV $&EAV"
echo "RESULT ID2 $&ID2"
echo "RESULT VD2 $&VD2"
echo "RESULT IDREV $&IDREV"
wrdata ind.txt v(d) id v(g)
.endc
.end
