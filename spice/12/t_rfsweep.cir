* 12 积分电路 · 参数与调试篇 图 12-p3-1：R = 10 kΩ、C = 100 nF，R_f = 10k / 100k / 1M / 10M。(a) ±1 V 500 Hz + 20 mV 偏置时输出中心；(b) 无偏置时三角波峰峰值
* LM358B（TI 官方模型），±15 V；仿 2 s，取最后 0.1 s（中心）/ 最后一个周期（峰峰）
.include ../models/LMx58B_LM2904B.lib
.options method=gear reltol=1e-4 rshunt=1e12
VP vcc 0 15
VN vee 0 -15
VR rst 0 PWL(0 1 49u 1 50u 0)
.model swr sw vt=0.5 vh=0.1 ron=1 roff=1e15
* 理想积分器：R 输入，C 反馈；电容旁的开关只在 t < 50 μs 时闭合，给电容清零（代替“初始输出 0 V”），之后断开（1e15 Ω）
.subckt integ in o vcc vee rst r=10k c=100n
R1 in m {r}
C1 m o {c}
S1 m o rst 0 swr
XA 0 m vcc vee o LMX58B_LM2904B
.ends
* 实用积分器：C 旁并 R_f，有直流工作点，不需要清零
.subckt pinteg in o vcc vee r=10k c=100n rf=1meg
R1 in m {r}
C1 m o {c}
R2 m o {rf}
XA 0 m vcc vee o LMX58B_LM2904B
.ends
VA a 0 PULSE(-1 1 50u 100n 100n 0.0009999 0.002)
VO ai a 20m
R1r10k ai mr10k 10k
C1r10k mr10k or10k 100n
R2r10k mr10k or10k 10k
S1r10k mr10k or10k rst 0 swr
XAr10k 0 mr10k vcc vee or10k LMX58B_LM2904B
R1br10k a mbr10k 10k
C1br10k mbr10k obr10k 100n
R2br10k mbr10k obr10k 10k
S1br10k mbr10k obr10k rst 0 swr
XAbr10k 0 mbr10k vcc vee obr10k LMX58B_LM2904B
R1r100k ai mr100k 10k
C1r100k mr100k or100k 100n
R2r100k mr100k or100k 100k
S1r100k mr100k or100k rst 0 swr
XAr100k 0 mr100k vcc vee or100k LMX58B_LM2904B
R1br100k a mbr100k 10k
C1br100k mbr100k obr100k 100n
R2br100k mbr100k obr100k 100k
S1br100k mbr100k obr100k rst 0 swr
XAbr100k 0 mbr100k vcc vee obr100k LMX58B_LM2904B
R1r1m ai mr1m 10k
C1r1m mr1m or1m 100n
R2r1m mr1m or1m 1meg
S1r1m mr1m or1m rst 0 swr
XAr1m 0 mr1m vcc vee or1m LMX58B_LM2904B
R1br1m a mbr1m 10k
C1br1m mbr1m obr1m 100n
R2br1m mbr1m obr1m 1meg
S1br1m mbr1m obr1m rst 0 swr
XAbr1m 0 mbr1m vcc vee obr1m LMX58B_LM2904B
R1r10m ai mr10m 10k
C1r10m mr10m or10m 100n
R2r10m mr10m or10m 10meg
S1r10m mr10m or10m rst 0 swr
XAr10m 0 mr10m vcc vee or10m LMX58B_LM2904B
R1br10m a mbr10m 10k
C1br10m mbr10m obr10m 100n
R2br10m mbr10m obr10m 10meg
S1br10m mbr10m obr10m rst 0 swr
XAbr10m 0 mbr10m vcc vee obr10m LMX58B_LM2904B
.control
tran 4u 2 0 4u
meas tran c_r10k avg v(or10k) from=1.9 to=2
echo "RES c_r10k $&c_r10k"
meas tran bx_r10k find v(obr10k) at=1.901048
meas tran bn_r10k find v(obr10k) at=1.902048
let bp_r10k = abs(bx_r10k - bn_r10k)
echo "RES bp_r10k $&bp_r10k"
meas tran c_r100k avg v(or100k) from=1.9 to=2
echo "RES c_r100k $&c_r100k"
meas tran bx_r100k find v(obr100k) at=1.901048
meas tran bn_r100k find v(obr100k) at=1.902048
let bp_r100k = abs(bx_r100k - bn_r100k)
echo "RES bp_r100k $&bp_r100k"
meas tran c_r1m avg v(or1m) from=1.9 to=2
echo "RES c_r1m $&c_r1m"
meas tran bx_r1m find v(obr1m) at=1.901048
meas tran bn_r1m find v(obr1m) at=1.902048
let bp_r1m = abs(bx_r1m - bn_r1m)
echo "RES bp_r1m $&bp_r1m"
meas tran c_r10m avg v(or10m) from=1.9 to=2
echo "RES c_r10m $&c_r10m"
meas tran bx_r10m find v(obr10m) at=1.901048
meas tran bn_r10m find v(obr10m) at=1.902048
let bp_r10m = abs(bx_r10m - bn_r10m)
echo "RES bp_r10m $&bp_r10m"
.endc
.end
