* 12 page3 练习5：12 V 单电源，两个 10 kΩ 分压得 6 V，分压点并 10 µF（页面 10～100 µF 取 10 µF），接 LM358B 跟随器，输出作 6 V 偏置；上限约 10.5 V
* 负载：三个运放同相端（几乎不取电流），这里不接负载。为了收敛，分压器上端用 1 ms 内 0→12 V 的源，电容经 5 kΩ 充电（时间常数 50 ms），等 500 ms（10 倍时间常数）再读
* 6 V 稳定后再把分压器上端慢慢升到 24 V（分压点到 12 V），看输出 / 共模上限
.include ../models/LMx58B_LM2904B.lib
.options method=gear reltol=1e-4 rshunt=1e10
VP vcc 0 12
VD t 0 PWL(0 0 1m 12 500m 12 900m 24)
RA t d 10k
RB d 0 10k
CB d 0 10u
X1 d o vcc 0 o LMX58B_LM2904B
.control
tran 100u 900m
meas tran o6 find v(o) at=495m
meas tran omax max v(o)
echo "RES o6 $&o6"
echo "RES omax12 $&omax"
.endc
.end
