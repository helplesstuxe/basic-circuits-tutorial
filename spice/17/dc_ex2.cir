* 17 稳压管稳压 · 原理与实现篇 例 2：1N4742A（Diodes Inc. DI_1N4742A），R 390 Ω，输入 24 V，空载
.include ../models/1N47xxA_diodes_zener.lib
VIN in 0 DC 24
R1 in o 390
XZ za o DI_1N4742A
VZM za 0 0
.control
op
let x = i(VZM)
echo "RES iz $&x"
let x = v(o)
echo "RES vo $&x"
let x = v(o)*i(VZM)
echo "RES pz $&x"
let x = (v(in)-v(o))*(v(in)-v(o))/390
echo "RES pr $&x"
.endc
.end
