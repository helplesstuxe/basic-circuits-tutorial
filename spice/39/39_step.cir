* 39 恒流源的稳定性：V_REF 从 0.5 V 跳到 1.0 V（3 ms 时，上升沿 1 µs），看采样电阻电压 v(s) 的过冲与振铃（page3 故障排查「栅极振荡」、图39-p3-2）
* 电路同 39_ccs.cir（RL 47 Ω），两种接法：
*   COMP=1：RG 100 Ω + RF 1k + CF 10 nF（页面推荐）；COMP=0：RG≈0、RF≈0、CF≈0（运放输出直接接栅极、反相端直接接源极）
.include ../models/LMx58B_LM2904B.lib
.include ../models/IRLZ44N_infineon.lib
.param COMP=1
.param RGV={COMP*100+(1-COMP)*0.01}
.param RFV={COMP*1000+(1-COMP)*0.01}
.param CFV={COMP*10n+(1-COMP)*1p}
VCC vcc 0 12
VR ref 0 PWL(0 0 1m 0.5 3m 0.5 3.001m 1.0)
XA ref fb vcc 0 oa LMX58B_LM2904B
RG oa g {RGV}
X1 d g s irlz44n
RS s 0 10
RF s fb {RFV}
CF oa fb {CFV}
RL vcc d 47
.control
foreach c 1 0
  alterparam COMP = $c
  reset
  tran 0.05u 3.4m 2.9m 0.05u
  meas tran vpk max v(s) from=3m to=3.4m
  meas tran vfin find v(s) at=3.39m
  meas tran tr when v(s)=0.95 rise=1
  meas tran vmin min v(s) from=3.05m to=3.4m
  meas tran vmx2 max v(s) from=3.2m to=3.4m
  meas tran vmn2 min v(s) from=3.2m to=3.4m
  * 过冲按理想终值 1.0 V 算（无补偿时一直振荡，vfin 只是某一瞬间的值，不能当终值）
  let os = (vpk-1.0)/0.5*100
  let rip = vmx2-vmn2
  let trs = (tr-3m)*1e6
  echo "RES os_$c $&os"
  echo "RES vfin_$c $&vfin"
  echo "RES tr_$c $&trs"
  echo "RES rip_$c $&rip"
  wrdata step_{$c}_vg.txt v(s)
end
* 无补偿那次（最后一次运行）的振荡频率：数 10 个上穿
meas tran tc1 when v(s)=vfin rise=10 from=3.2m
meas tran tc2 when v(s)=vfin rise=20 from=3.2m
let fosc = 10/(tc2-tc1)
echo "RES fosc_0 $&fosc"
.endc
.end
