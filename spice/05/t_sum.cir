* 05 page2 例3 图05-p2-4：反相加法器，三个电阻 10 kΩ，V1=0.5 V 1 kHz，V2=0.2 V 5 kHz → 输出最高 0.70 V
.include ../models/LMx58B_LM2904B.lib
.options method=gear reltol=1e-4 rshunt=1e10
VP vcc 0 15
VN vee 0 -15
V1 a 0 SIN(0 0.5 1k)
V2 b 0 SIN(0 0.2 5k)
R1 a m 10k
R2 b m 10k
RF m o 10k
X1 0 m vcc vee o LMX58B_LM2904B
.control
tran 1u 4m
meas tran omax max v(o) from=2m to=4m
meas tran omin min v(o) from=2m to=4m
echo "RES omax $&omax"
echo "RES omin $&omin"
.endc
.end
