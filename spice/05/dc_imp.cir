* 05 page2 例2：改进型，R1 = 10k，Rf = 20k；page3 练习3：R1 = 10k，Rf = 50k / 56k，信号源内阻 Rs = 1k
* 页面：例2 Vi = −0.1 V → Vo = 0.2 V，运放脚 0.9 V；Vi = +0.1 V → 运放脚 −0.7 V，Vo = 0
*       练习3 Rf = 50k、Rs = 1k → 增益 4.55；Rf = 56k → 5.09
* LM741 ±15 V，1N4148，RL = 10k（假设，页面代码取 10k）。输入慢爬，读 9 ms
.include ../models/LM741_TI.lib
.include ../models/1N4148_nexperia.lib
.options method=gear reltol=1e-4
VP vcc 0 15
VN vee 0 -15
VR r 0 PWL(0 0 5m 1)
EI i 0 r 0 -0.1
RS i s 0.001
X1 0 m vcc vee oa LM741
R1 s m 10k
RF o m 20k
XD1 oa o 1N4148
XD2 m oa 1N4148
RL o 0 10k
.control
tran 10u 10m
meas tran on find v(o) at=9m
meas tran an find v(oa) at=9m
echo "RES on $&on"
echo "RES an $&an"
alter EI gain=0.1
tran 10u 10m
meas tran op find v(o) at=9m
meas tran ap find v(oa) at=9m
echo "RES op $&op"
echo "RES ap $&ap"
alter EI gain=-0.1
alter RS resistance=1k
alter RF resistance=50k
tran 10u 10m
meas tran o50 find v(o) at=9m
echo "RES o50 $&o50"
alter RF resistance=56k
tran 10u 10m
meas tran o56 find v(o) at=9m
echo "RES o56 $&o56"
alter RS resistance=0.001
alter RF resistance=50k
tran 10u 10m
meas tran o50n find v(o) at=9m
echo "RES o50n $&o50n"
.endc
.end
