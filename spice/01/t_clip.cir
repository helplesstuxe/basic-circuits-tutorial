* 01 page2 §二 仿真/图01-p2-2 右图：10k/100k，±15 V，输入 1.5 V 峰值 1 kHz → 被削在 13.50 V / −14.90 V
* 同时对应 page3 练习3(1)（2 V 峰值：削在 −14.9～13.5 V），两者削顶电平相同
.include ../models/LMx58B_LM2904B.lib
.options method=gear reltol=1e-4 rshunt=1e10
VP vcc 0 15
VN vee 0 -15
VA a 0 SIN(0 1.5 1k)
R1a a ma 10k
RFa ma oa 100k
XA 0 ma vcc vee oa LMX58B_LM2904B
.control
tran 2u 4m
meas tran omax max v(oa) from=2m to=4m
meas tran omin min v(oa) from=2m to=4m
echo "RES omax $&omax"
echo "RES omin $&omin"
.endc
.end
