* 01 page1 §五 第3步：10k/100k，±15 V，加大输入：约 1.35 V 时正半周在 13.5 V 削平，约 1.49 V 时负半周在 −14.9 V 削平
* 用缓慢的三角波（−2 V→+2 V→−2 V，每段 10 ms）代替直流扫描（直流扫描在饱和处不收敛），
* 找输出上下限以及输出到达上下限 99% 时的输入电压
.include ../models/LMx58B_LM2904B.lib
.options method=gear reltol=1e-4 rshunt=1e10
VP vcc 0 15
VN vee 0 -15
VI a 0 PWL(0 -2 10m 2 20m -2)
R1a a ma 10k
RFa ma oa 100k
XA 0 ma vcc vee oa LMX58B_LM2904B
.control
tran 5u 20m
meas tran vhi max v(oa)
meas tran vlo min v(oa)
let th=0.99*vhi
let tl=0.99*vlo
meas tran tih when v(oa)=th fall=1
meas tran til when v(oa)=tl fall=1
let vih=-2+4*tih/10m
let vil=-2+4*til/10m
echo "RES vhi $&vhi"
echo "RES vlo $&vlo"
echo "RES vih $&vih"
echo "RES vil $&vil"
.endc
.end
