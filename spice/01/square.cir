* 01 方波驱动 RC（page2 §4 图01-p2-3）：0–5 V 方波，R=10k，C=100µF（τ=1 s）
* 半周期 = 3τ：稳态最高 4.76 V / 最低 0.24 V；半周期 = 1τ：1.34–3.65 V，平均约 2.5 V
* 假设：与图一致，方波从 0 V 起步、电容初始 0 V；取第 10 个周期以后的稳态峰谷
Va a 0 PULSE(0 5 0 1u 1u 3 6)
Ra a ca 10k
Ca ca 0 100u IC=0
Vb b 0 PULSE(0 5 0 1u 1u 1 2)
Rb b cb 10k
Cb cb 0 100u IC=0
.control
tran 2m 66 uic
meas tran amax max v(ca) from=60 to=66
meas tran amin min v(ca) from=60 to=66
meas tran bmax max v(cb) from=60 to=66
meas tran bmin min v(cb) from=60 to=66
meas tran bavg avg v(cb) from=60 to=66
echo "RES amax $&amax"
echo "RES amin $&amin"
echo "RES bmax $&bmax"
echo "RES bmin $&bmin"
echo "RES bavg $&bavg"
.endc
.end
