* 01 反相放大 直流工作点（LM358B，±15 V，输出无外接负载）
* page1 §一 0.5 V→−5 V、−0.2 V→+2 V；page2 第二步 I=0.05 mA、P3 结论 −4.99945 V / V−≈50 µV
* page1 §五 第2步 Rf=47k（−4.7 倍）、Rf=10k（−1 倍）；page1 §五 第5步 反相端零点几毫伏
* page2 例1 R1=10k Rf=20k 1 V→−2 V、0.1 mA；例2 20k/100k 0.3 V→−1.5 V；例3 加法器 0.5+0.2→−0.7 V
* page3 练习1 4.7k/47k −0.2 V→+2 V；练习4 Rf=50k R1=10k R2=50k，0.1/0.3 V→−0.8 V
.include ../models/LMx58B_LM2904B.lib
VP vcc 0 15
VN vee 0 -15
V05 i05 0 0.5
V02 i02 0 -0.2
V1 i1 0 1
V03 i03 0 0.3
VS2 is2 0 0.2
VS1 is1 0 0.1
* A：10k/100k，0.5 V
R1a i05 ma 10k
RFa ma oa 100k
XA 0 ma vcc vee oa LMX58B_LM2904B
* B：10k/100k，−0.2 V
R1b i02 mb 10k
RFb mb ob 100k
XB 0 mb vcc vee ob LMX58B_LM2904B
* C：10k/47k，0.5 V
R1c i05 mc 10k
RFc mc oc 47k
XC 0 mc vcc vee oc LMX58B_LM2904B
* D：10k/10k，0.5 V
R1d i05 md 10k
RFd md od 10k
XD 0 md vcc vee od LMX58B_LM2904B
* E：例1 10k/20k，1 V
R1e i1 me 10k
RFe me oe 20k
XE 0 me vcc vee oe LMX58B_LM2904B
* F：例2 20k/100k，0.3 V
R1f i03 mf 20k
RFf mf of 100k
XF 0 mf vcc vee of LMX58B_LM2904B
* G：例3 加法器 10k/10k/10k，0.5 V + 0.2 V
R1g i05 mg 10k
R2g is2 mg 10k
RFg mg og 10k
XG 0 mg vcc vee og LMX58B_LM2904B
* H：练习1 4.7k/47k，−0.2 V
R1h i02 mh 4.7k
RFh mh oh 47k
XH 0 mh vcc vee oh LMX58B_LM2904B
* K：练习4 R1=10k（0.1 V）、R2=50k（0.3 V）、Rf=50k
R1k is1 mk 10k
R2k i03 mk 50k
RFk mk ok 50k
XK 0 mk vcc vee ok LMX58B_LM2904B
.control
op
let ia=(v(i05)-v(ma))/10k
let ie=(v(i1)-v(me))/10k
echo "RES voa $&v(oa)"
echo "RES vma $&v(ma)"
echo "RES ia $&ia"
echo "RES vob $&v(ob)"
echo "RES voc $&v(oc)"
echo "RES vod $&v(od)"
echo "RES voe $&v(oe)"
echo "RES ie $&ie"
echo "RES vof $&v(of)"
echo "RES vog $&v(og)"
echo "RES voh $&v(oh)"
echo "RES vok $&v(ok)"
.endc
.end
