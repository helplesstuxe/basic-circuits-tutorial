* 13 page2 例3：一只二极管半波整流 + 2200 µF + 0.2 A 恒流负载，12 V 有效值次级串 1 Ω（假设），1N4007 模型替代 1N4001
* 页面：纹波 ≈ I/(fC) ≈ 1.82 V（公式），最高约 16.97 − 0.7 = 16.27 V，二极管反向电压约 33 V
.include ../models/1N4007_diodes.lib
.options method=gear reltol=1e-4
VS s 0 SIN(0 16.97056 50)
RS s a 1
D1 a p DI_1N4007
C1 p 0 2200u
IL p 0 0.2
.control
tran 20u 1 0 20u
meas tran hmx max v(p) from=0.96 to=1
meas tran hpp pp v(p) from=0.96 to=1
let vr = v(a)-v(p)
meas tran hrv min vr from=0.96 to=1
echo "RES hmx $&hmx"
echo "RES hpp $&hpp"
echo "RES hrv $&hrv"
.endc
.end
