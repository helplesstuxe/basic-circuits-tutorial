* P3 page2 图P3-p2-3 开环：0.5 V 峰值 1 kHz 接同相端，反相端接地，±15 V，无负载
.include ../models/LMx58B_LM2904B.lib
.options method=gear reltol=1e-4 rshunt=1e10
VP vcc 0 15
VN vee 0 -15
VA a 0 SIN(0 0.5 1k)
X1 a 0 vcc vee o LMX58B_LM2904B
.control
tran 2u 4m
meas tran omax max v(o) from=2m to=4m
meas tran omin min v(o) from=2m to=4m
echo "RES omax $&omax"
echo "RES omin $&omin"
.endc
.end
