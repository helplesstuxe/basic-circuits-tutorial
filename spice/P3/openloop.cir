* P3 LM358B 开环参数（TI 官方 PSpice 模型）
* 对应：page1 §二（A 典型 14 万，取 10 万；±15 V 时输出上下限 ±13.5 V）；page3 参数表（A 14 万/最小 7 万、摆幅、GBW 1.2 MHz、SR 0.5 V/µs）
* 负载假设：页面未写负载，摆幅按 10 kΩ 接地（手册摆幅测试条件同量级）
.include ../models/LMx58B_LM2904B.lib
VP vcc 0 15
VN vee 0 -15
* 开环增益/GBW：直流用大电感闭环定工作点，交流时电感开路、电容把反相端交流接地
VI inp 0 DC 0 AC 1
XU1 inp inm vcc vee out LMX58B_LM2904B
L1 out inm 1e9
C1 inm 0 1e6
* 失调电压：跟随器
XU2 inp2 out2 vcc vee out2 LMX58B_LM2904B
VI2 inp2 0 0
* 输出摆幅（±15 V，10 kΩ 负载）：开环 ±1 V 差分
XU3 hi 0 vcc vee o3 LMX58B_LM2904B
Vhi hi 0 1
RL3 o3 0 10k
XU4 0 hi vcc vee o4 LMX58B_LM2904B
RL4 o4 0 10k
* 摆幅（±5 V 和 5 V 单电源，10 kΩ 负载接地）
V5p v5p 0 5
V5n v5n 0 -5
XU5 hi 0 v5p v5n o5 LMX58B_LM2904B
RL5 o5 0 10k
XU6 0 hi v5p v5n o6 LMX58B_LM2904B
RL6 o6 0 10k
XU7 hi 0 v5p 0 o7 LMX58B_LM2904B
RL7 o7 0 10k
XU8 0 hi v5p 0 o8 LMX58B_LM2904B
RL8 o8 0 10k
.control
op
let vos=v(out2)
let vhi15=v(o3)
let vlo15=v(o4)
let vhi5=v(o5)
let vlo5=v(o6)
let vhis=v(o7)
let vlos=v(o8)
echo "RES vos $&vos"
echo "RES vhi15 $&vhi15"
echo "RES vlo15 $&vlo15"
echo "RES vhi5 $&vhi5"
echo "RES vlo5 $&vlo5"
echo "RES vhis $&vhis"
echo "RES vlos $&vlos"
ac dec 20 1e-4 1e7
let mag=abs(v(out))
meas ac a0 find mag at=1e-3
meas ac fu when mag=1 fall=1
meas ac a10k find mag at=1e4
meas ac a1e4 find mag at=1e-4
let gbw=a10k*1e4
echo "RES gbw $&gbw"
echo "RES a1e4 $&a1e4"
echo "RES a0 $&a0"
echo "RES fu $&fu"
.endc
.end
