* P3 page2 图P3-p2-3 有负反馈：0.5 V 峰值 1 kHz，R1 10k，Rf 100k，±15 V，无负载
.include ../models/LMx58B_LM2904B.lib
.options method=gear reltol=1e-4 rshunt=1e10
VP vcc 0 15
VN vee 0 -15
VA a 0 SIN(0 0.5 1k)
R1 a m 10k
RF m o 100k
X1 0 m vcc vee o LMX58B_LM2904B
.control
tran 2u 4m
meas tran omax max v(o) from=2m to=4m
meas tran omin min v(o) from=2m to=4m
echo "RES omax $&omax"
echo "RES omin $&omin"
.endc
.end
