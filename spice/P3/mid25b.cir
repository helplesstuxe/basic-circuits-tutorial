* P3 page3 练习4 对照：中点 2.5 V 时输入 0.17 V 峰值（应削顶）
.include ../models/LMx58B_LM2904B.lib
.options method=gear reltol=1e-4 rshunt=1e10
VP vcc 0 5
VM mid 0 2.5
VA a 0 SIN(2.5 0.17 1k)
R1 a m 10k
RF m o 100k
X1 mid m vcc 0 o LMX58B_LM2904B
RL o 0 10k
.control
tran 2u 4m
meas tran omax max v(o) from=2m to=4m
meas tran omin min v(o) from=2m to=4m
echo "RES omax $&omax"
echo "RES omin $&omin"
.endc
.end
