* 28 光耦回升：page1 §四 图28-p1-2（通用光耦接 1.9 kΩ 上拉：拉低约 0.5 µs、回升约 40 µs 过 2.5 V、下一个脉冲前约 4.07 V）；
*   page3 故障表“100 Ω 上拉时约 3 µs”。页面数字来自 TI 白皮书 SLLA526D 里的“通用光耦”，型号与 I_F 页面未给；这里假设 PC817、5 V 单片机脚经 RIN 给 I_F≈5 mA、CTR 100%。
* 5 kHz 方波：0～100 µs LED 亮，100～200 µs 熄灭（输出回升）。
.include ../models/PC817_ltspice.lib
*@def VIN=12
*@def RIN=2.2k
*@def VCC=5
*@def RL=4.7k
*@def IGAIN=2e-4
*@def TSTOP=400u
VIN in 0 PULSE(@VIN@ 0 100u 50n 50n 100u 200u)
RIN in a @RIN@
XU1 a 0 out g2 PC817 Igain=@IGAIN@
RG2 g2 0 1m
VCC vcc 0 @VCC@
RL vcc out @RL@
.control
tran 20n @TSTOP@ 0 20n
wrdata rise.dat v(out)
echo "RESULT DONE 1"
.endc
.end
