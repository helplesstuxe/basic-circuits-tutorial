* 26 H 桥：page1 图26-p1-3「正转 0–0.4 s → 滑行 0.4–0.7 s → 正转 0.7–1.1 s → 刹车 1.1–1.3 s → 反转 1.3–1.8 s」
*   及其下方三条读数（5377 rpm、4.56 A、3988 rpm、184 rpm、−4.36 A、−4.71 A、−5383 rpm）。
* 没有 DRV8871 的 SPICE 模型（TI 的 DRV8871-Q1 页面只挂了 DRV8876-Q1 的 PSpice 模型，不是同一颗芯片），
* 桥臂用 ngspice 理想开关：Ron 取页面的 DRV8871 典型值（高边 0.307 Ω、低边 0.258 Ω），每管并一只通用体二极管
* （ngspice 内建 D 模型，IS=1e-9 N=1.6，约 0.3 A 时 0.8 V，对应页面 V_D≈0.8 V 的假设，不是 DRV8871 实测）。
* 电机：页面参数 R=2 Ω、L=1 mH、Ke=0.02 V·s/rad、J=1e-5 kg·m²、b=1e-5；机械部分用等效电路：
*   节点 w 的电压 = 角速度（rad/s），C=J、R=1/b，转矩 Ke·i 作为电流源注入。
VM vm 0 12
.model SWH SW(Ron=0.307 Roff=10Meg Vt=0.5 Vh=0)
.model SWL SW(Ron=0.258 Roff=10Meg Vt=0.5 Vh=0)
.model DB D(IS=1e-9 N=1.6)
S1 vm a g1 0 SWH
S3 a 0 g3 0 SWL
S2 vm b g2 0 SWH
S4 b 0 g4 0 SWL
D1 a vm DB
D3 0 a DB
D2 b vm DB
D4 0 b DB
RM a m1 2
LM m1 m2 1m
VS m2 m3 0
BE m3 b V=0.02*v(w)
BT 0 w I=0.02*i(VS)
CJ w 0 1e-5
RB w 0 1e5
V1 g1 0 PWL(0 1 0.4 1 0.400001 0 0.7 0 0.700001 1 1.1 1 1.100001 0)
V4 g4 0 PWL(0 1 0.4 1 0.400001 0 0.7 0 0.700001 1 1.3 1 1.300001 0)
V3 g3 0 PWL(0 0 1.1 0 1.100001 1)
V2 g2 0 PWL(0 0 1.3 0 1.300001 1)
.ic v(w)=0
.control
tran 2u 1.8 0 5u uic
let rpm = v(w)*60/(2*pi)
let i = i(VS)
meas tran wfull FIND rpm AT=0.399
meas tran wcoast FIND rpm AT=0.699
meas tran wfull2 FIND rpm AT=1.099
meas tran wbrake FIND rpm AT=1.299
meas tran wend FIND rpm AT=1.8
meas tran istart MAX i FROM=0 TO=0.05
meas tran ibrake MIN i FROM=1.1 TO=1.3
meas tran irev MIN i FROM=1.3 TO=1.8
meas tran t98 WHEN rpm=5270 RISE=1
echo "RESULT WFULL $&wfull"
echo "RESULT WCOAST $&wcoast"
echo "RESULT WFULL2 $&wfull2"
echo "RESULT WBRAKE $&wbrake"
echo "RESULT WEND $&wend"
echo "RESULT ISTART $&istart"
echo "RESULT IBRAKE $&ibrake"
echo "RESULT IREV $&irev"
echo "RESULT T98 $&t98"
.endc
.end
