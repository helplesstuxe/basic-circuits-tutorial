* 26 H 桥：page3 扫描一下方的文字「06 节单片机经 100 Ω 栅极电阻直接驱动 IRLZ44N，关断就要 0.7 µs 左右；那样的电路死区要留到 1 µs 量级」。
* 用 Infineon IRLZ44N 官方模型搭一个半桥（Q1 上管、Q3 下管），两只管子都经 100 Ω 由 0/5 V 驱动；
* 上管的驱动源以 A 点为参考（相当于理想自举 / 隔离驱动，假设）。12 V、走线 20 nH，A 点不接负载，只看直通。
* 上管驱动在 t=1 µs 从 5 V 跳到 0；下管驱动在 1 µs + TDEAD 从 0 跳到 5 V。
.include ../models/IRLZ44N_infineon.lib
*@def TDEAD=0
VM vm 0 12
LS vm vmi 20n
VSUP vmi d1 0
XQ1 d1 gh a irlz44n
XQ3 a gl 0 irlz44n
RGH gh hsrc 100
VDH hsrc a PWL(0 5 1u 5 1.005u 0)
RGL gl lsrc 100
VDL lsrc 0 PWL(0 0 {1u+@TDEAD@} 0 {1.005u+@TDEAD@} 5)
.control
tran 1n 6u 0 1n
let i = i(VSUP)
meas tran ipk MAX i FROM=1u TO=6u
let p = 12*i
meas tran e INTEG p FROM=1u TO=6u
echo "RESULT IPK $&ipk"
echo "RESULT E $&e"
.endc
.end
