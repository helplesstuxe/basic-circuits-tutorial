* 09 page2 §1 代数（Vi = 0.1 V 直流）与 例1（Vi = 50 mV 直流）：基本型精密整流，LM741 ±15 V，1N4148，RL = 10k
* 页面：0.1 V → Vo ≈ 0.1 V，运放脚 ≈ 0.8 V，误差约 8 µV；50 mV → 运放脚 ≈ 0.75 V，误差 7.5 µV
* 输入从 0 慢爬到终值（瞬态，避开 op），读 9 ms 时稳态
.include ../models/LM741_TI.lib
.include ../models/1N4148_nexperia.lib
.options method=gear reltol=1e-4
VP vcc 0 15
VN vee 0 -15
VR r 0 PWL(0 0 5m 1)
EI i 0 r 0 0.1
X1 i o vcc vee oa LM741
XD1 oa o 1N4148
RL o 0 10k
.control
tran 10u 10m
meas tran o1 find v(o) at=9m
meas tran a1 find v(oa) at=9m
echo "RES o1 $&o1"
echo "RES a1 $&a1"
alter EI gain=0.05
tran 10u 10m
meas tran o2 find v(o) at=9m
meas tran a2 find v(oa) at=9m
echo "RES o2 $&o2"
echo "RES a2 $&a2"
alter EI gain=0.2
tran 10u 10m
meas tran o3 find v(o) at=9m
echo "RES o3 $&o3"
alter EI gain=0.01
tran 10u 10m
meas tran o4 find v(o) at=9m
echo "RES o4 $&o4"
.endc
.end
