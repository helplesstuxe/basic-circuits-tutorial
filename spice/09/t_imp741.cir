* 09 精密整流 page2 §2～§3 / page3 §2～§3：改进型 + LM741（图09-p2-4 / 图09-p3-1 第三行 / 图09-p3-2 红紫线）
* 页面：1 kHz 平均值误差 −0.5%，运放脚 −0.70～0.90 V；10 kHz −5.3%；约 2 kHz 碰 1%
* 输入峰值 0.2 V 正弦，±15 V（页面）；R 均 10 kΩ（页面代码 R1=RF=RL=10k）；二极管用 1N4148（page3 推荐，页面仿真用 0.7 V 折线模型）
* 平均值误差 = 第二个周期 v(o) 平均 ÷ (0.2/π) − 1，与页面代码定义相同
.include ../models/LM741_TI.lib
.include ../models/1N4148_nexperia.lib
.options method=gear reltol=1e-4
VP vcc 0 15
VN vee 0 -15
VI i 0 SIN(0 0.2 1k)
* 改进型（反相型）：R1 从 Vi 到反相端 m，同相端接地；D2 阳极 oa → 阴极 m；按页面：D1 从运放输出脚指向输出端，D2 从反相端指向运放输出脚
* 页面原文"D2 从反相端（虚地）接到运放输出脚"：输入为正时 Voa 压到 −0.7 V D2 导通，故 D2 阳极 = m、阴极 = oa；D1 阳极 = oa、阴极 = o
X1 0 m vcc vee oa LM741
R1 i m 10k
RF o m 10k
XD1 oa o 1N4148
XD2 m oa 1N4148
RL o 0 10k
.control
tran 5e-07 0.002 0 5e-07
meas tran av_1k avg v(o) from=0.001 to=0.002
meas tran lo_1k min v(oa) from=0.001 to=0.002
meas tran hi_1k max v(oa) from=0.001 to=0.002
echo "RES av_1k $&av_1k"
echo "RES lo_1k $&lo_1k"
echo "RES hi_1k $&hi_1k"
alter @VI[sin] = [ 0 0.2 2000 ]
tran 2.5e-07 0.001 0 2.5e-07
meas tran av_2k avg v(o) from=0.0005 to=0.001
meas tran lo_2k min v(oa) from=0.0005 to=0.001
meas tran hi_2k max v(oa) from=0.0005 to=0.001
echo "RES av_2k $&av_2k"
echo "RES lo_2k $&lo_2k"
echo "RES hi_2k $&hi_2k"
alter @VI[sin] = [ 0 0.2 5000 ]
tran 1e-07 0.0004 0 1e-07
meas tran av_5k avg v(o) from=0.0002 to=0.0004
meas tran lo_5k min v(oa) from=0.0002 to=0.0004
meas tran hi_5k max v(oa) from=0.0002 to=0.0004
echo "RES av_5k $&av_5k"
echo "RES lo_5k $&lo_5k"
echo "RES hi_5k $&hi_5k"
alter @VI[sin] = [ 0 0.2 10000 ]
tran 5e-08 0.0002 0 5e-08
meas tran av_10k avg v(o) from=0.0001 to=0.0002
meas tran lo_10k min v(oa) from=0.0001 to=0.0002
meas tran hi_10k max v(oa) from=0.0001 to=0.0002
echo "RES av_10k $&av_10k"
echo "RES lo_10k $&lo_10k"
echo "RES hi_10k $&hi_10k"
alter @VI[sin] = [ 0 0.2 20000 ]
tran 2.5e-08 0.0001 0 2.5e-08
meas tran av_20k avg v(o) from=5e-05 to=0.0001
meas tran lo_20k min v(oa) from=5e-05 to=0.0001
meas tran hi_20k max v(oa) from=5e-05 to=0.0001
echo "RES av_20k $&av_20k"
echo "RES lo_20k $&lo_20k"
echo "RES hi_20k $&hi_20k"
.endc
.end
