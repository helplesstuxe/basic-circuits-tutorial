* 19 page2 图19-p2-2 / page1 §4：基极输入 5 V ± 2 V、50 Hz 正弦，12 V 电源，50 Ω 负载（只在仿真里看，页面说明不要照着搭）
* 页面：输出 2.31~6.28 V，V_BE 0.694~0.720 V，交流增益 0.994，峰值处输入 7.00 V / 输出 6.28 V，差 0.72 V
* 基极由理想源推动；Q1 = 2N3904，Q2 = TIP31C
.include ../models/2N3904_onsemi.lib
.include ../models/TIP31C_onsemi.lib
VB b 0 SIN(5 2 50)
VC c 0 12
Q1 c b e1 Q2n3904
Q2 c b e2 Qtip31c
RL1 e1 0 50
RL2 e2 0 50
.control
tran 20u 40m 0 20u
let vbe1 = v(b)-v(e1)
let vbe2 = v(b)-v(e2)
meas tran mx1 max v(e1)
meas tran mn1 min v(e1)
meas tran mx2 max v(e2)
meas tran mn2 min v(e2)
meas tran bx1 max vbe1
meas tran bn1 min vbe1
meas tran bx2 max vbe2
meas tran bn2 min vbe2
echo "RES mx1 $&mx1"
echo "RES mn1 $&mn1"
echo "RES mx2 $&mx2"
echo "RES mn2 $&mn2"
echo "RES bx1 $&bx1"
echo "RES bn1 $&bn1"
echo "RES bx2 $&bx2"
echo "RES bn2 $&bn2"
.endc
.end
