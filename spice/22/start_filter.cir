* 22 过载保护 · 参数与调试篇 图 22-p3-2 (b)：启动冲击 1 + 4e^(−t/20 ms) A 经 0.1 Ω 采样、R_F 10 kΩ 与 C_F 滤波（τ = 10 / 47 / 100 ms）的峰值（开环）；
* 以及 练习 2：冲击改为 1 + 4e^(−t/50 ms) A 时 τ = 47 / 100 ms 的峰值。纯 RC 部分，不含比较器。
B20 s20 0 V = 0.1*(1+4*exp(-time/0.02))
B50 s50 0 V = 0.1*(1+4*exp(-time/0.05))
R1 s20 f10 10k
C1 f10 0 1u
R2 s20 f47 10k
C2 f47 0 4.7u
R3 s20 f100 10k
C3 f100 0 10u
R4 s50 g47 10k
C4 g47 0 4.7u
R5 s50 g100 10k
C5 g100 0 10u
.ic v(f10)=0 v(f47)=0 v(f100)=0 v(g47)=0 v(g100)=0
.control
tran 20u 0.5 0 20u
meas tran raw max v(s20)
meas tran p10 max v(f10)
meas tran p47 max v(f47)
meas tran p100 max v(f100)
meas tran q47 max v(g47)
meas tran q100 max v(g100)
let dg = deriv(v(g47))
meas tran tq47 when dg=0 cross=1
let ex = (v(s20)*10)^2 - 1
meas tran i2t integ ex from=0 to=0.5
echo "RES tq47 $&tq47"
echo "RES i2t $&i2t"
echo "RES raw $&raw"
echo "RES p10 $&p10"
echo "RES p47 $&p47"
echo "RES p100 $&p100"
echo "RES q47 $&q47"
echo "RES q100 $&q100"
.endc
.end
