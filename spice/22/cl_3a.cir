* 22 过载保护 · 原理与实现篇 例题 1 (2)：电机从 1 A 突然变成 3 A，多久跳闸
* 图 22-p2-1 完整电路：低边 R_S 0.1 Ω、R_F 10 kΩ / C_F 10u、LM393（TI LM393A 官方宏模型）、R_A 33k / R_B 1k / R_H 100k、上拉 2.2 kΩ、IRLZ44N（Infineon）
* 电机（页面只给 12 V、正常 1 A、堵转约 5 A）：按反电动势 + 线圈电阻 2.28 Ω + 电感 1 mH 建模（假设，使堵转电流约 5 A）；续流二极管 D1 用 Vishay 1N5822（页面未给型号，替代）
.include ../models/LM393A.lib
.include ../models/IRLZ44N_infineon.lib
.include ../models/1N5822_vishay.lib
V12 vm 0 12
V5 v5 0 5
XD1 d vm d1n5822
RM vm m1 2.28
LM m1 m2 1m
BEMF m2 m3 V = time < 0.1 ? 9.6 : 4.8
VIM m3 d 0
XM d g s irlz44n
RS s 0 0.1
RF s f 10k
CF f 0 10u
RA v5 p 33k
RB p 0 1k
RH p g 100k
RPU v5 g 2.2k
XU p f v5 0 g LM393A
.options method=gear
.control
tran 10u 0.3 0 10u
meas tran t1 when v(g)=2.5 fall=1
let ttrip = t1 - 0.1
echo "RES ttrip $&ttrip"
meas tran i3 avg i(VIM) from=0.12 to=0.15
echo "RES i3 $&i3"
.endc
.end
