* 22 过载保护 · 参数与调试篇 图 22-p3-2 (b) 的闭环版：电机从静止启动（冲击 5 A 按 20 ms 回落到 1 A），τ = 47 ms
* 图 22-p2-1 完整电路：低边 R_S 0.1 Ω、R_F 10 kΩ / C_F 4.7u、LM393（TI LM393A 官方宏模型）、R_A 33k / R_B 1k / R_H 100k、上拉 2.2 kΩ、IRLZ44N（Infineon）
* 电机（页面只给 12 V、正常 1 A、堵转约 5 A）：按反电动势 + 线圈电阻 2.28 Ω + 电感 1 mH 建模（假设，使堵转电流约 5 A）；续流二极管 D1 用 Vishay 1N5822（页面未给型号，替代）
* 反电动势按 9.6·(1−e^(−t/20 ms)) 上升，使电流 = 1 + 4e^(−t/20 ms) A（页面的启动冲击）
.include ../models/LM393A.lib
.include ../models/IRLZ44N_infineon.lib
.include ../models/1N5822_vishay.lib
V12 vm 0 12
V5 v5 0 5
XD1 d vm d1n5822
RM vm m1 2.28
LM m1 m2 1m
BEMF m2 m3 V = 9.6*(1-exp(-time/0.02))
VIM m3 d 0
XM d g s irlz44n
RS s 0 0.1
RF s f 10k
CF f 0 4.7u
RA v5 p 33k
RB p 0 1k
RH p g 100k
RPU v5 g 2.2k
XU p f v5 0 g LM393A
.ic v(f)=0
.options method=gear
.control
tran 10u 0.3 0 10u
meas tran vgmin min v(g) from=1m to=0.3
echo "RES vgmin $&vgmin"
meas tran vfpk max v(f)
echo "RES vfpk $&vfpk"
.endc
.end
