* 22 过载保护 · 参数与调试篇 面包板万用表读数：图 22-p2-1 完整电路，正常运行 1 A（t = 90 ms）与堵转跳闸后断开期间（首次跳闸后 5 ms）各点电压；直觉篇 §三 “1 A 对应 0.1 V”
* 图 22-p2-1 完整电路：低边 R_S 0.1 Ω、R_F 10 kΩ / C_F 10u、LM393（TI LM393A 官方宏模型）、R_A 33k / R_B 1k / R_H 100k、上拉 2.2 kΩ、IRLZ44N（Infineon）
* 电机（页面只给 12 V、正常 1 A、堵转约 5 A）：按反电动势 + 线圈电阻 2.28 Ω + 电感 1 mH 建模（假设，使堵转电流约 5 A）；续流二极管 D1 用 Vishay 1N5822（页面未给型号，替代）
.include ../models/LM393A.lib
.include ../models/IRLZ44N_infineon.lib
.include ../models/1N5822_vishay.lib
V12 vm 0 12
V5 v5 0 5
XD1 d vm d1n5822
RM vm m1 2.28
LM m1 m2 1m
BEMF m2 m3 V = time < 0.1 ? 9.6 : 0
VIM m3 d 0
XM d g s irlz44n
RS s 0 0.1
RF s f 10k
CF f 0 10u
RA v5 p 33k
RB p 0 1k
RH p g 100k
RPU v5 g 2.2k
XU p f v5 0 g LM393A
.options method=gear
.control
tran 10u 0.16 0 10u
meas tran run_s find v(s) at=0.09
echo "RES run_s $&run_s"
meas tran off_s find v(s) at=0.1317
echo "RES off_s $&off_s"
meas tran run_f find v(f) at=0.09
echo "RES run_f $&run_f"
meas tran off_f find v(f) at=0.1317
echo "RES off_f $&off_f"
meas tran run_p find v(p) at=0.09
echo "RES run_p $&run_p"
meas tran off_p find v(p) at=0.1317
echo "RES off_p $&off_p"
meas tran run_g find v(g) at=0.09
echo "RES run_g $&run_g"
meas tran off_g find v(g) at=0.1317
echo "RES off_g $&off_g"
meas tran run_d find v(d) at=0.09
echo "RES run_d $&run_d"
meas tran off_d find v(d) at=0.1317
echo "RES off_d $&off_d"
meas tran run_i find i(VIM) at=0.09
echo "RES run_i $&run_i"
meas tran off_i find i(VIM) at=0.1317
echo "RES off_i $&off_i"
meas tran gmin min v(g) from=0.1 to=0.16
echo "RES gmin $&gmin"
.endc
.end
