* 22 图22-p3-1（page3 §一）：R_B 从 100 Ω 扫到 100 kΩ（run.py 逐点调用），看线圈电压占额定的百分比，找跌破 75% 吸合门限的 R_B。
* 电路同 relay.cir 的稳态：5 V → 70 Ω 线圈 → 2N3904（onsemi 官方模型）；引脚 5 V 经 RB 接基极。只做直流工作点。
* 页面三条线是 β=30/100/300 的分段模型；SPICE 只有一只“典型”2N3904，所以只能给出它自己的那一条线。
.include ../models/2N3904_onsemi.lib
*@def RB=680
VCC vcc 0 5
RC vcc c 70
VIN pin 0 5
RB pin b @RB@
Q1 c b 0 Q2n3904
.control
op
let pct = (5 - v(c))/5*100
echo "RESULT PCT $&pct"
.endc
.end
