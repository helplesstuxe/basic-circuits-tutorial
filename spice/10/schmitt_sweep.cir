* 10 电压比较器：page1 图10-p1-1/图10-p1-3、page2 §2 门限计算与图10-p2-1 回差曲线、page3 §2 R2 扫描、练习3
* LM393A（TI 官方模型）5 V 单电源；反相端 10k/10k 分压得 2.5 V；R1 输入电阻，R2 正反馈，R3 上拉到 VPU。
* 基本比较器（图10-p1-1）用 R1=1m、R2=1e12 近似「无 R1/R2」。输入 2.0 V -> 3.0 V -> 2.0 V 慢速三角波（各 20 ms）。
.include ../models/LM393A.lib
.param R1=10k R2=100k R3=2.2k VPU=5
VCC vcc 0 5
VP vpu 0 {VPU}
RA vcc ref 10k
RB ref 0 10k
VIN in 0 PWL(0 2.0 20m 3.0 40m 2.0)
RR1 in p {R1}
RR2 p out {R2}
RR3 vpu out {R3}
XU p ref vcc 0 out LM393A
.control
tran 2u 40m 0 2u
*@def VHALF=2.5
meas tran vh FIND v(in) WHEN v(out)=@VHALF@ RISE=1
meas tran vl FIND v(in) WHEN v(out)=@VHALF@ FALL=1
meas tran vol AVG v(out) FROM=2m TO=8m
meas tran voh AVG v(out) FROM=22m TO=28m
meas tran vref AVG v(ref) FROM=1m TO=2m
echo "RESULT vh $&vh"
echo "RESULT vl $&vl"
echo "RESULT vol $&vol"
echo "RESULT voh $&voh"
echo "RESULT vref $&vref"
.endc
.end
