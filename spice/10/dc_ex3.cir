* 10 稳压管稳压 · 原理与实现篇 例 3：R 560 Ω、1N4733A + NPN 功率管射极跟随器，14 V 输入，负载 0 / 200 mA（电流源）
* 页面只写「NPN 功率三极管，β 按 60 估算」，未给型号；这里用 onsemi TIP31C 官方模型代表（替代，假设）
.include ../models/1N47xxA_diodes_zener.lib
.include ../models/TIP31C_onsemi.lib
VIN in 0 DC 14
R1 in b 560
XZ za b DI_1N4733A
VZM za 0 0
VCM in c 0
Q1 c b o Qtip31c
IL o 0 DC 0
.control
op
let x = i(VZM)
echo "RES iz0 $&x"
alter IL dc = 0.2
op
let x = i(VZM)
echo "RES iz200 $&x"
let x = v(b)
echo "RES vb200 $&x"
let x = v(o)
echo "RES vo200 $&x"
let x = (v(c)-v(o))*i(VCM)
echo "RES pc200 $&x"
alter VIN dc = 10
op
let x = i(VZM)
echo "RES iz200_10 $&x"
.endc
.end
