* 18 微分电路：page1 图18-p1-3 / page2 图18-p2-3 / page3 图18-p3-1 与练习1
* 反相微分器，LM358B（TI 官方模型），±15 V 供电。C=100nF, Rf=10k；R1、Cf 可选（实用微分器）。
* 输入：±VM 三角波，频率 FT（默认 ±0.5 V、500 Hz，斜率 ±1 V/ms），可叠加 AN 幅度、20 kHz 正弦干扰。
* 理想微分器用 R1=1m（近似 0）、Cf=1e-18（近似开路）。
.include ../models/LMx58B_LM2904B.lib
.param R1=1m
.param CF=1e-18
.param AN=0
.param VM=0.5
.param FT=500
*@def TSTOP=8m
VP vp 0 15
VN vn 0 -15
VT tri 0 PULSE({-VM} {VM} 0 {0.5/FT} {0.5/FT} 1n {1/FT})
VNZ in tri SIN(0 {AN} 20k)
R1 in a {R1}
C1 a m 100n
RF m out 10k
CF m out {CF}
XU 0 m vp vn out LMX58B_LM2904B
.control
tran 0.5u @TSTOP@ 0 0.5u
wrdata out.txt v(out) v(in)
echo "RESULT done 1"
.endc
.end
