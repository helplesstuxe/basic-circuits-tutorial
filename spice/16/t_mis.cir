* 16 page2 §二 仿真 / 图16-p2-2：差分信号 10 Hz、幅度 10 mV（V2 − V1），两根线同时骑 2 V、50 Hz 共模干扰；R1=R3=10k，R2=R4=100k
* 页面：匹配时输出峰值 100 mV；R4 偏大 1%（101k）时峰值 118 mV（漏进约 18 mV 的 50 Hz）
* 另：page1 §四 第5步，两根输入短接后接干扰源（差分信号设为 0），看输出残留（匹配 / R4 偏大 1%）
* LM358B，±15 V（假设）。V1 = Vcm − Vd/2，V2 = Vcm + Vd/2；源都从 0 开始，避开 TI 模型的 op 不收敛
* 读 50～200 ms 的输出最大值/最小值
.include ../models/LMx58B_LM2904B.lib
.options method=gear reltol=1e-4
VP vcc 0 15
VN vee 0 -15
VCM c 0 SIN(0 2 50)
VDA n2 c SIN(0 5m 10)
VDB c n1 SIN(0 5m 10)
R1 n1 m 10k
R2 m o 100k
R3 n2 p 10k
R4 p 0 100k
X1 p m vcc vee o LMX58B_LM2904B
.control
tran 20u 200m
meas tran okmax max v(o) from=50m to=200m
meas tran okmin min v(o) from=50m to=200m
echo "RES okmax $&okmax"
echo "RES okmin $&okmin"
alter R4 resistance=101k
tran 20u 200m
meas tran bdmax max v(o) from=50m to=200m
meas tran bdmin min v(o) from=50m to=200m
echo "RES bdmax $&bdmax"
echo "RES bdmin $&bdmin"
alter @VDA[sin] = [ 0 0 10 ]
alter @VDB[sin] = [ 0 0 10 ]
tran 20u 200m
meas tran shbmax max v(o) from=50m to=200m
meas tran shbmin min v(o) from=50m to=200m
echo "RES shbmax $&shbmax"
echo "RES shbmin $&shbmin"
alter R4 resistance=100k
tran 20u 200m
meas tran shmax max v(o) from=50m to=200m
meas tran shmin min v(o) from=50m to=200m
echo "RES shmax $&shmax"
echo "RES shmin $&shmin"
.endc
.end
