* 25 开关电源 · page3 练习 3：24 V->5 V、2 A（2.5 Ω），L 33 µH，C 47 µF，理想同步元件，D=5/24
.param D=0.20833333333333334 T=5u tr=20n
VIN in 0 24
CIN in 0 10u
S1 in sw g 0 SWM
VG g 0 PULSE(0 1 {tr} {tr} {tr} {D*T-tr} {T})
.model SWM SW(VT=0.5 VH=0.01 RON=0.001 ROFF=1e7)
.include ../models/1N5822_vishay.lib
VDI 0 da 0
S2 sw da gl 0 SWL
.model SWL SW(VT=0.5 VH=0.01 RON=0.001 ROFF=1e7)
VGL gl 0 PULSE(1 0 0 {tr} {tr} {D*T+tr} {T})
XDB da sw d1n5822
L1 sw lx 3.3e-05 IC=2
RDCR lx o 1e-06
CO o 0 4.7e-05 IC=5.0
RL o 0 2.5
.control
tran 2n 4.000000m 0 4n uic
meas tran vo avg v(o) from=3.995000m to=4.000000m
meas tran vpp pp v(o) from=3.995000m to=4.000000m
meas tran ilmin min i(L1) from=3.995000m to=4.000000m
meas tran ilmax max i(L1) from=3.995000m to=4.000000m
meas tran vswlo find v(sw) at=3.999750m
meas tran vswhi find v(sw) at=3.995417m
meas tran ia1 find i(L1) at=3.995260m
meas tran ia2 find i(L1) at=3.995781m
meas tran ib1 find i(L1) at=3.997031m
meas tran ib2 find i(L1) at=3.999010m
let sup = (ia2-ia1)/(5.208333333333334e-07)/1000
let sdn = (ib1-ib2)/(1.9791666666666666e-06)/1000
let pdv = (v(da)-v(sw))*i(VDI)
meas tran pd avg pdv from=3.995000m to=4.000000m
meas tran idav avg i(VDI) from=3.995000m to=4.000000m
let pinv = -v(in)*i(VIN)
meas tran pin avg pinv from=3.995000m to=4.000000m
let plv = v(o)*v(o)/2.5
meas tran pout avg plv from=3.995000m to=4.000000m
let psv = (v(in)-v(sw))*(-i(VIN))
meas tran pq avg psv from=3.995000m to=4.000000m
echo "RES vo $&vo"
echo "RES vpp $&vpp"
echo "RES ilmin $&ilmin"
echo "RES ilmax $&ilmax"
echo "RES vswlo $&vswlo"
echo "RES vswhi $&vswhi"
echo "RES sup $&sup"
echo "RES sdn $&sdn"
echo "RES pd $&pd"
echo "RES idav $&idav"
echo "RES pin $&pin"
echo "RES pout $&pout"
echo "RES pq $&pq"
.endc
.end
