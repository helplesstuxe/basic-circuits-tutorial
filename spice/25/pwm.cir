* 25 H 桥：page2「仿真：20 kHz PWM 调速」图25-p2-2、代数小结、例1/例2；page3 扫描二 图25-p3-2 与频率表。
* 「驱动—刹车」PWM：S4 常通，S1 在周期前 D·T 导通、S3 在其余时间导通（S1/S3 之间留 20 ns 死区，期间电流走 S3 的体二极管）。
* 开关 / 体二极管 / 电机等效电路同 seq.cir（理想开关，Ron 取 DRV8871 典型值，无 DRV8871 SPICE 模型）。
*@def F=20k
*@def D=0.5
*@def TSTOP=0.4
*@def W0=0
*@def I0=0
*@def TA=0.39
*@def MAXSTEP=0.5u
VM vm 0 12
.model SWH SW(Ron=0.307 Roff=10Meg Vt=0.5 Vh=0)
.model SWL SW(Ron=0.258 Roff=10Meg Vt=0.5 Vh=0)
.model DB D(IS=1e-9 N=1.6)
.param per={1/@F@} ton={@D@/@F@}
S1 vm a g1 0 SWH
S3 a 0 g3 0 SWL
S2 vm b 0 0 SWH
S4 b 0 g4 0 SWL
D1 a vm DB
D3 0 a DB
D2 b vm DB
D4 0 b DB
V1 g1 0 PULSE(0 1 0 5n 5n {ton-5n} {per})
V3 g3 0 PULSE(0 1 {ton+20n} 5n 5n {per-ton-45n} {per})
V4 g4 0 1
RM a m1 2
LM m1 m2 1m IC=@I0@
VS m2 m3 0
BE m3 b V=0.02*v(w)
BT 0 w I=0.02*i(VS)
CJ w 0 1e-5 IC=@W0@
RB w 0 1e5
.control
tran 0.1u @TSTOP@ 0 @MAXSTEP@ uic
let rpm = v(w)*60/(2*pi)
let i = i(VS)
meas tran wavg AVG rpm FROM=@TA@ TO=@TSTOP@
meas tran iavg AVG i FROM=@TA@ TO=@TSTOP@
meas tran imax MAX i FROM=@TA@ TO=@TSTOP@
meas tran imin MIN i FROM=@TA@ TO=@TSTOP@
let vab = v(a)-v(b)
meas tran vavg AVG vab FROM=@TA@ TO=@TSTOP@
echo "RESULT WAVG $&wavg"
echo "RESULT IAVG $&iavg"
echo "RESULT IMAX $&imax"
echo "RESULT IMIN $&imin"
echo "RESULT VAVG $&vavg"
@EXTRA@
.endc
.end
