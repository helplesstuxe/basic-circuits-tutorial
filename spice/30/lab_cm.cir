* 30 page4 共模测试（与面包板一致）：J1 插着（RX 被短接），J2 把电桥两个中点（第 5 列、第 13 列）短在一起 → 差模为 0；
* 再插 RC 4.7k：从第 13 列（j13）插到下面的 0 V 轨 → 共模被拉低；改插到下面的 V+ 轨 → 共模被抬高（J2 已把两中点连在一起，接哪个中点都一样）。读两次 Vo−M，相减
* 情形：c0 四只差分电阻全等；c1 R10 下面串 100 Ω（10.1k，失配 1%）；c2 5% 最坏（R7、R10 偏大 5%，R8、R9 偏小 5%）；c3 = c1 再拔掉 RG（第一级倍数 1）
.include ../models/LMx58B_LM2904B.lib
.options method=gear reltol=1e-4
VB vp 0 9
VX vx 0 PWL(0 0 1m 9)
RM1 vx md 10k
RM2 md 0 10k
XU2B md m vp 0 m LMX58B_LM2904B
R1 vx va 10k
R2 va 0 10k
R3 vx vb 10k
R4 vb 0 10k
RJ2 va vb 1m
RCL va 0 4.7k
RCH vx va 1e12
XA1 va n1 vp 0 o1 LMX58B_LM2904B
XA2 vb n2 vp 0 o2 LMX58B_LM2904B
R5 o1 n1 10k
R6 o2 n2 10k
RG n1 n2 1k
R7 o1 n3 10k
R8 n3 out 10k
R9 o2 n4 10k
R10 n4 m 10k
XA3 n4 n3 vp 0 out LMX58B_LM2904B
.control
let k = 0
foreach x 1 2 3 4
  if k = 1
    alter R10 resistance=10.1k
  end
  if k = 2
    alter R7 resistance=10.5k
    alter R10 resistance=10.5k
    alter R8 resistance=9.5k
    alter R9 resistance=9.5k
  end
  if k = 3
    alter R7 resistance=10k
    alter R8 resistance=10k
    alter R9 resistance=10k
    alter R10 resistance=10.1k
    alter RG resistance=1e9
  end
  alter RCL resistance=4.7k
  alter RCH resistance=1e12
  tran 5u 2m 0 5u
  let voo = v(out)-v(m)
  meas tran lo find voo at=1.9m
  meas tran vcl find v(va) at=1.9m
  echo "RES lo_c$&k $&lo"
  echo "RES vcl_c$&k $&vcl"
  alter RCL resistance=1e12
  alter RCH resistance=4.7k
  tran 5u 2m 0 5u
  let voo = v(out)-v(m)
  meas tran hi find voo at=1.9m
  meas tran vch find v(va) at=1.9m
  echo "RES hi_c$&k $&hi"
  echo "RES vch_c$&k $&vch"
  let k = k + 1
end
.endc
.end
