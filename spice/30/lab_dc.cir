* 30 page4：单节 9 V + 中点参考 V_MID（网表节点 m）（10k/10k 分压 + LM358 跟随器）+ 4×10k 电桥 + 三运放仪表放大器（R=10k，RG=1k，差分级四只 10k）
* 电桥右下臂：面包板上是 R4 9.1k 串 RP1（2k 多圈，调到约 0.9k）；这里直接用精确的 10k 代表“已调平”，没有 RP1，所以 RX = 0 时的输出就是不调零的模型失调。右下臂再串 RX；RX = 0/100/220/470 Ω；最后把 RG 拔掉（1 GΩ 代替）看倍数 1
* 用瞬态：电池 1 ms 内从 0 升到 9 V，1.9 ms 时读稳态（避开 TI 模型的 op 不收敛）
.include ../models/LMx58B_LM2904B.lib
.options method=gear reltol=1e-4
VB vp 0 9
* 电桥与中点参考 V_MID分压的激励在实物里就是电池 vp；仿真里用同值的 VX 从 0 慢慢升到 9 V（1 ms），稳态与接 vp 完全相同，只为避开初始工作点不收敛
VX vx 0 PWL(0 0 1m 9)
RM1 vx md 10k
RM2 md 0 10k
XU2B md m vp 0 m LMX58B_LM2904B
R1 vx va 10k
R2 va 0 10k
R3 vx vb 10k
R4 vb x 10k
RX x 0 1m
XA1 va n1 vp 0 o1 LMX58B_LM2904B
XA2 vb n2 vp 0 o2 LMX58B_LM2904B
R5 o1 n1 10k
R6 o2 n2 10k
RG n1 n2 1k
R7 o1 n3 10k
R8 n3 out 10k
R9 o2 n4 10k
R10 n4 m 10k
XA3 n4 n3 vp 0 out LMX58B_LM2904B
.control
let k = 0
foreach rx 1m 100 220 470
  alter RX resistance=$rx
  tran 1u 2m 0 1u
  let vdd = v(vb)-v(va)
  meas tran vd find vdd at=1.9m
  let voo = v(out)-v(m)
  meas tran vo find voo at=1.9m
  meas tran vm find v(m) at=1.9m
  meas tran a1 find v(o1) at=1.9m
  meas tran a2 find v(o2) at=1.9m
  echo "RES vd_$&k $&vd"
  echo "RES vo_$&k $&vo"
  echo "RES vm_$&k $&vm"
  echo "RES a1_$&k $&a1"
  echo "RES a2_$&k $&a2"
  let k = k + 1
end
alter RG resistance=1e9
tran 1u 2m 0 1u
let vdd = v(vb)-v(va)
  meas tran vd find vdd at=1.9m
let voo = v(out)-v(m)
  meas tran vo find voo at=1.9m
echo "RES vd_g1 $&vd"
echo "RES vo_g1 $&vo"
.endc
.end
