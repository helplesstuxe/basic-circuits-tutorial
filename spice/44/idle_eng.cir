* 44 对照：同一个前级（实际约 38.6 kHz），输出 LC 换成 100 µH + 0.33 µF（f0 ≈ 20 kHz），看静音时负载上的载波残余
.include front.inc
.include comp_ad.inc
.include drv.inc
.include lc_eng.inc
R10 x1 y 10
R8 y x2 8
VS sig 0 0
.ic v(sq)=10.5 v(tri)=6
.options reltol=1e-3 method=gear
.control
tran 20n 4m 0 50n
let vd = v(x1)-v(x2)
meas tran iavg avg i(Vam) from=2m to=4m
meas tran vdrms rms vd from=2m to=4m
meas tran ilmax max i(L1) from=2m to=4m
meas tran ilmin min i(L1) from=2m to=4m
echo "RES eng_iavg $&iavg"
echo "RES eng_vdrms $&vdrms"
echo "RES eng_ilmax $&ilmax"
echo "RES eng_ilmin $&ilmin"
.endc
.end
