* 03 page3 图03-p3-2：5 V 单电源（V− 接地）LM358B 跟随器，输入 0→5 V（20 ms 线性斜坡），输出无外接负载
* 页面：输入高于 3.5 V 输出被削平在 3.5 V；输入接近 0 时输出最低只到约 0.1 V
.include ../models/LMx58B_LM2904B.lib
.options method=gear reltol=1e-4 rshunt=1e10
VP vcc 0 5
VS i 0 PWL(0 0 20m 5)
X1 i o vcc 0 o LMX58B_LM2904B
BE e 0 V=v(i)-v(o)-0.05
.control
tran 10u 20m
meas tran omax max v(o)
meas tran omin min v(o)
meas tran oat0 find v(o) at=10u
meas tran vfail find v(i) when v(e)=0 cross=last
echo "RES omax $&omax"
echo "RES omin $&omin"
echo "RES oat0 $&oat0"
echo "RES vfail $&vfail"
.endc
.end
