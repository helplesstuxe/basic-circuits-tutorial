* 03 page3 §3：LM358B 压摆率典型 0.5 V/µs —— 跟随器 ±15 V，输入 −5 V→+5 V 阶跃（上升 10 ns），输出空载
* 读输出从 −2.5 V 升到 +2.5 V 所用时间，算平均上升压摆率；反向阶跃同理
.include ../models/LMx58B_LM2904B.lib
.options method=gear reltol=1e-4 rshunt=1e10
VP vcc 0 15
VN vee 0 -15
VS i 0 PWL(0 -5 50u -5 50.01u 5 150u 5 150.01u -5)
X1 i o vcc vee o LMX58B_LM2904B
.control
tran 10n 250u
meas tran tr1 when v(o)=-2.5 rise=1
meas tran tr2 when v(o)=2.5 rise=1
meas tran tf1 when v(o)=2.5 fall=1
meas tran tf2 when v(o)=-2.5 fall=1
let srr = 5/(tr2-tr1)/1e6
let srf = 5/(tf2-tf1)/1e6
echo "RES srr $&srr"
echo "RES srf $&srf"
.endc
.end
