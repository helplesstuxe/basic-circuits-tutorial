* 03 page2 例3 / 图03-p2-3：2.5 V 基准缓冲。5 V 经两只 10 kΩ 分压，分压点并 100 nF 到地，接 LM358B 跟随器（5 V 单电源）
* 页面只给定性结论："负载突然抽电流时，由运放的输出级及时补上，基准电压几乎不跳"
* 假设：模数转换器参考端每次采样抽 1 mA、持续 1 µs 的电流脉冲（页面没给数值），比较器门限端不取电流；
*       对照组：同一脉冲直接从 100 nF 分压点抽取（不加跟随器）
* 收敛说明同 t_ex1ss.cir：电路地 g（运放 V− 脚）放在 −2.5 V，V+ 在 +2.5 V，电位差与单 5 V 相同；分压器上端 1 ms 内 0→5 V，等 15 ms 稳定
.include ../models/LMx58B_LM2904B.lib
.options method=gear reltol=1e-4 rshunt=1e10
VP vcc 0 2.5
VG g 0 -2.5
VD t g PWL(0 0 1m 5)
RA t d 10k
RB d g 10k
CF d g 100n
X1 d o vcc g o LMX58B_LM2904B
IADC o g PULSE(0 1m 15m 10n 10n 1u 1)
RA2 t d2 10k
RB2 d2 g 10k
CF2 d2 g 100n
IADC2 d2 g PULSE(0 1m 15m 10n 10n 1u 1)
.control
tran 5n 15.05m 14.9m
let vo = v(o)-v(g)
let vd2 = v(d2)-v(g)
meas tran o0 find vo at=14.95m
meas tran omin min vo from=15m to=15.05m
meas tran omax max vo from=15m to=15.05m
meas tran o1 find vo at=15.04m
meas tran d0 find vd2 at=14.95m
meas tran dmin min vd2 from=15m to=15.05m
echo "RES o0 $&o0"
echo "RES omin $&omin"
echo "RES omax $&omax"
echo "RES o1 $&o1"
echo "RES d0 $&d0"
echo "RES dmin $&dmin"
.endc
.end
